********************************************************************
** 64x32 SRAM Array Subcircuit Definition                          **
********************************************************************
.include './extracted_netlists/SRAM_array.pex.netlist'
.include './extracted_netlists/SA.pex.netlist'

.subckt SRAM_Array_64x32_with_SA
+ PRE SAEN VDD VSS VDD_W VSS_SUB
* --- 以下是 64 條共享的 Wordlines ---
+ WL0  WL1  WL2  WL3  WL4  WL5  WL6  WL7  WL8  WL9  WL10 WL11 WL12 WL13 WL14 WL15
+ WL16 WL17 WL18 WL19 WL20 WL21 WL22 WL23 WL24 WL25 WL26 WL27 WL28 WL29 WL30 WL31
+ WL32 WL33 WL34 WL35 WL36 WL37 WL38 WL39 WL40 WL41 WL42 WL43 WL44 WL45 WL46 WL47
+ WL48 WL49 WL50 WL51 WL52 WL53 WL54 WL55 WL56 WL57 WL58 WL59 WL60 WL61 WL62 WL63

* --- 以下是 32 組獨立的控制與輸出線 (以 Column 0 ~ 31 命名) ---
* Column 0
+ SENSE_OUT0 SENSE_OUTB0 WEN_BL0 WEN_BLB0
* Column 1
+ SENSE_OUT1 SENSE_OUTB1  WEN_BL1  WEN_BLB1
* Column 2
+ SENSE_OUT2 SENSE_OUTB2  WEN_BL2  WEN_BLB2
* Column 3
+ SENSE_OUT3 SENSE_OUTB3  WEN_BL3  WEN_BLB3
* Column 4
+ SENSE_OUT4 SENSE_OUTB4  WEN_BL4  WEN_BLB4
* Column 5
+ SENSE_OUT5 SENSE_OUTB5  WEN_BL5  WEN_BLB5
* Column 6
+ SENSE_OUT6 SENSE_OUTB6  WEN_BL6  WEN_BLB6
* Column 7
+ SENSE_OUT7 SENSE_OUTB7  WEN_BL7  WEN_BLB7
* Column 8
+ SENSE_OUT8 SENSE_OUTB8  WEN_BL8  WEN_BLB8
* Column 9
+ SENSE_OUT9 SENSE_OUTB9  WEN_BL9  WEN_BLB9
* Column 10
+ SENSE_OUT10 SENSE_OUTB10 WEN_BL10 WEN_BLB10
* Column 11
+ SENSE_OUT11 SENSE_OUTB11 WEN_BL11 WEN_BLB11
* Column 12
+ SENSE_OUT12 SENSE_OUTB12 WEN_BL12 WEN_BLB12
* Column 13
+ SENSE_OUT13 SENSE_OUTB13 WEN_BL13 WEN_BLB13
* Column 14
+ SENSE_OUT14 SENSE_OUTB14 WEN_BL14 WEN_BLB14
* Column 15
+ SENSE_OUT15 SENSE_OUTB15 WEN_BL15 WEN_BLB15
* Column 16
+ SENSE_OUT16 SENSE_OUTB16 WEN_BL16 WEN_BLB16
* Column 17
+ SENSE_OUT17 SENSE_OUTB17 WEN_BL17 WEN_BLB17
* Column 18
+ SENSE_OUT18 SENSE_OUTB18 WEN_BL18 WEN_BLB18
* Column 19
+ SENSE_OUT19 SENSE_OUTB19 WEN_BL19 WEN_BLB19
* Column 20
+ SENSE_OUT20 SENSE_OUTB20 WEN_BL20 WEN_BLB20
* Column 21
+ SENSE_OUT21 SENSE_OUTB21 WEN_BL21 WEN_BLB21
* Column 22
+ SENSE_OUT22 SENSE_OUTB22 WEN_BL22 WEN_BLB22
* Column 23
+ SENSE_OUT23 SENSE_OUTB23 WEN_BL23 WEN_BLB23
* Column 24
+ SENSE_OUT24 SENSE_OUTB24 WEN_BL24 WEN_BLB24
* Column 25
+ SENSE_OUT25 SENSE_OUTB25 WEN_BL25 WEN_BLB25
* Column 26
+ SENSE_OUT26 SENSE_OUTB26 WEN_BL26 WEN_BLB26
* Column 27
+ SENSE_OUT27 SENSE_OUTB27 WEN_BL27 WEN_BLB27
* Column 28
+ SENSE_OUT28 SENSE_OUTB28 WEN_BL28 WEN_BLB28
* Column 29
+ SENSE_OUT29 SENSE_OUTB29 WEN_BL29 WEN_BLB29
* Column 30
+ SENSE_OUT30 SENSE_OUTB30 WEN_BL30 WEN_BLB30
* Column 31
+ SENSE_OUT31 SENSE_OUTB31 WEN_BL31 WEN_BLB31

xSRAM_Array_64x32  PRE BL0 VDD BLB0 BL1 BLB1 BL2 BLB2 BL3 BLB3 BL4 BLB4
+ BL5 BLB5 BL6 BLB6 BL7 BLB7 BL8 BLB8 BL9 BLB9 BL10 BLB10 BL11 BLB11 BL12 BLB12
+ BL13 BLB13 BL14 BLB14 BL15 BLB15 BL16 BLB16 BL17 BLB17 BL18 BLB18 BL19 BLB19
+ BL20 BLB20 BL21 BLB21 BL22 BLB22 BL23 BLB23 BL24 BLB24 BL25 BLB25 BL26 BLB26
+ BL27 BLB27 BL28 BLB28 BL29 BLB29 BL30 BLB30 BL31 BLB31 VSS WEN_BL0 WEN_BLB0
+ WEN_BL1 WEN_BLB1 WEN_BL2 WEN_BLB2 WEN_BL3 WEN_BLB3 WEN_BL4 WEN_BLB4 WEN_BL5
+ WEN_BLB5 WEN_BL6 WEN_BLB6 WEN_BL7 WEN_BLB7 WEN_BL8 WEN_BLB8 WEN_BL9 WEN_BLB9
+ WEN_BL10 WEN_BLB10 WEN_BL11 WEN_BLB11 WEN_BL12 WEN_BLB12 WEN_BL13 WEN_BLB13
+ WEN_BL14 WEN_BLB14 WEN_BL15 WEN_BLB15 WEN_BL16 WEN_BLB16 WEN_BL17 WEN_BLB17
+ WEN_BL18 WEN_BLB18 WEN_BL19 WEN_BLB19 WEN_BL20 WEN_BLB20 WEN_BL21 WEN_BLB21
+ WEN_BL22 WEN_BLB22 WEN_BL23 WEN_BLB23 WEN_BL24 WEN_BLB24 WEN_BL25 WEN_BLB25
+ WEN_BL26 WEN_BLB26 WEN_BL27 WEN_BLB27 WEN_BL28 WEN_BLB28 WEN_BL29 WEN_BLB29
+ WEN_BL30 WEN_BLB30 WEN_BL31 WEN_BLB31 WL0 WL1 WL2 WL3 WL4 WL5 WL6 WL7 WL8 WL9
+ WL10 WL11 WL12 WL13 WL14 WL15 WL16 WL17 WL18 WL19 WL20 WL21 WL22 WL23 WL24
+ WL25 WL26 WL27 WL28 WL29 WL30 WL31 WL32 WL33 WL34 WL35 WL36 WL37 WL38 WL39
+ WL40 WL41 WL42 WL43 WL44 WL45 WL46 WL47 WL48 WL49 WL50 WL51 WL52 WL53 WL54
+ WL55 WL56 WL57 WL58 WL59 WL60 WL61 WL62 WL63 VSS_SUB VDD_W
+ SRAM_Array_64x32

xSA_col0 VSS SAEN SENSE_OUTB0 VDD SENSE_OUT0 BL0 BLB0 VSS_SUB VDD_W SA
xSA_col1 VSS SAEN SENSE_OUTB1 VDD SENSE_OUT1 BL1 BLB1 VSS_SUB VDD_W SA
xSA_col2 VSS SAEN SENSE_OUTB2 VDD SENSE_OUT2 BL2 BLB2 VSS_SUB VDD_W SA
xSA_col3 VSS SAEN SENSE_OUTB3 VDD SENSE_OUT3 BL3 BLB3 VSS_SUB VDD_W SA
xSA_col4 VSS SAEN SENSE_OUTB4 VDD SENSE_OUT4 BL4 BLB4 VSS_SUB VDD_W SA
xSA_col5 VSS SAEN SENSE_OUTB5 VDD SENSE_OUT5 BL5 BLB5 VSS_SUB VDD_W SA
xSA_col6 VSS SAEN SENSE_OUTB6 VDD SENSE_OUT6 BL6 BLB6 VSS_SUB VDD_W SA
xSA_col7 VSS SAEN SENSE_OUTB7 VDD SENSE_OUT7 BL7 BLB7 VSS_SUB VDD_W SA
xSA_col8 VSS SAEN SENSE_OUTB8 VDD SENSE_OUT8 BL8 BLB8 VSS_SUB VDD_W SA
xSA_col9 VSS SAEN SENSE_OUTB9 VDD SENSE_OUT9 BL9 BLB9 VSS_SUB VDD_W SA
xSA_col10 VSS SAEN SENSE_OUTB10 VDD SENSE_OUT10 BL10 BLB10 VSS_SUB VDD_W SA
xSA_col11 VSS SAEN SENSE_OUTB11 VDD SENSE_OUT11 BL11 BLB11 VSS_SUB VDD_W SA
xSA_col12 VSS SAEN SENSE_OUTB12 VDD SENSE_OUT12 BL12 BLB12 VSS_SUB VDD_W SA
xSA_col13 VSS SAEN SENSE_OUTB13 VDD SENSE_OUT13 BL13 BLB13 VSS_SUB VDD_W SA
xSA_col14 VSS SAEN SENSE_OUTB14 VDD SENSE_OUT14 BL14 BLB14 VSS_SUB VDD_W SA
xSA_col15 VSS SAEN SENSE_OUTB15 VDD SENSE_OUT15 BL15 BLB15 VSS_SUB VDD_W SA
xSA_col16 VSS SAEN SENSE_OUTB16 VDD SENSE_OUT16 BL16 BLB16 VSS_SUB VDD_W SA
xSA_col17 VSS SAEN SENSE_OUTB17 VDD SENSE_OUT17 BL17 BLB17 VSS_SUB VDD_W SA
xSA_col18 VSS SAEN SENSE_OUTB18 VDD SENSE_OUT18 BL18 BLB18 VSS_SUB VDD_W SA
xSA_col19 VSS SAEN SENSE_OUTB19 VDD SENSE_OUT19 BL19 BLB19 VSS_SUB VDD_W SA
xSA_col20 VSS SAEN SENSE_OUTB20 VDD SENSE_OUT20 BL20 BLB20 VSS_SUB VDD_W SA
xSA_col21 VSS SAEN SENSE_OUTB21 VDD SENSE_OUT21 BL21 BLB21 VSS_SUB VDD_W SA
xSA_col22 VSS SAEN SENSE_OUTB22 VDD SENSE_OUT22 BL22 BLB22 VSS_SUB VDD_W SA
xSA_col23 VSS SAEN SENSE_OUTB23 VDD SENSE_OUT23 BL23 BLB23 VSS_SUB VDD_W SA
xSA_col24 VSS SAEN SENSE_OUTB24 VDD SENSE_OUT24 BL24 BLB24 VSS_SUB VDD_W SA
xSA_col25 VSS SAEN SENSE_OUTB25 VDD SENSE_OUT25 BL25 BLB25 VSS_SUB VDD_W SA
xSA_col26 VSS SAEN SENSE_OUTB26 VDD SENSE_OUT26 BL26 BLB26 VSS_SUB VDD_W SA
xSA_col27 VSS SAEN SENSE_OUTB27 VDD SENSE_OUT27 BL27 BLB27 VSS_SUB VDD_W SA
xSA_col28 VSS SAEN SENSE_OUTB28 VDD SENSE_OUT28 BL28 BLB28 VSS_SUB VDD_W SA
xSA_col29 VSS SAEN SENSE_OUTB29 VDD SENSE_OUT29 BL29 BLB29 VSS_SUB VDD_W SA
xSA_col30 VSS SAEN SENSE_OUTB30 VDD SENSE_OUT30 BL30 BLB30 VSS_SUB VDD_W SA
xSA_col31 VSS SAEN SENSE_OUTB31 VDD SENSE_OUT31 BL31 BLB31 VSS_SUB VDD_W SA

.ends SRAM_Array_64x32_with_SA
