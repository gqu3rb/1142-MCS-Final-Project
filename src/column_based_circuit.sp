.title Column-based Peripheral Circuits
* ===================================================================
* 獨立元件庫：Column-based Peripheral Circuits
* 檔名：column_based_circuit.sp
* ===================================================================

* ------ 1. 基礎邏輯閘子電路(column decoder) ------
.subckt INV_c IN OUT VDD VSS VDD_W VSS_SUB
Mp OUT IN VDD VDD_W   pmos_lvt W=8.1e-08 L=2e-08 nfin=3
Mn OUT IN VSS VSS_SUB nmos_lvt W=8.1e-08 L=2e-08 nfin=3
.ends

.subckt DEC_1to2 IN OUT_b OUT VDD VSS VDD_W VSS_SUB
Xsel0 IN    OUT_b VDD VSS VDD_W VSS_SUB INV_c
Xsel1 OUT_b OUT   VDD VSS VDD_W VSS_SUB INV_c
.ends

.subckt AND2_c IN1 IN2 OUT VDD VSS VDD_W VSS_SUB
Mp1 OUT_b IN1 VDD VDD_W   pmos_lvt W=2.7e-08 L=2e-08 nfin=1
Mp2 OUT_b IN2 VDD VDD_W   pmos_lvt W=2.7e-08 L=2e-08 nfin=1
Mn1 OUT_b IN1 n1  VSS_SUB nmos_lvt W=2.7e-08 L=2e-08 nfin=3
Mn2 n1    IN2 VSS VSS_SUB nmos_lvt W=2.7e-08 L=2e-08 nfin=3
Xinv OUT_b OUT VDD VSS VDD_W VSS_SUB INV_c
.ends

.subckt WR_DRIVER WEN IN BL BLB VDD VSS VDD_W VSS_SUB
Xinv  IN  IN_b VDD VSS VDD_W VSS_SUB INV_c
Xand1 WEN IN   BL  VDD VSS   VDD_W   VSS_SUB AND2_c
Xand2 WEN IN_b BLB VDD VSS   VDD_W   VSS_SUB AND2_c
.ends

.subckt bl_to_wen_slice EN A A_b D WEN_BL0 WEN_BLB0 WEN_BL1 WEN_BLB1 VDD VSS VDD_W0 VDD_W1 VSS_SUB
Xand0 EN A_b WEN0 VDD VSS VDD_W0 VSS_SUB AND2_c
Xand1 EN A   WEN1 VDD VSS VDD_W1 VSS_SUB AND2_c

Xdriver0 WEN0 D WEN_BL0 WEN_BLB0 VDD VSS VDD_W0 VSS_SUB WR_DRIVER
Xdriver1 WEN1 D WEN_BL1 WEN_BLB1 VDD VSS VDD_W1 VSS_SUB WR_DRIVER
.ends

* ------ 2. 主解碼器核心 ------
.subckt COL_DRIVER_ARRAY In WEN
+ D0  D1  D2  D3  D4  D5  D6  D7
+ D8  D9  D10 D11 D12 D13 D14 D15
+ WEN_BL0  WEN_BL1  WEN_BL2  WEN_BL3  WEN_BL4  WEN_BL5  WEN_BL6  WEN_BL7
+ WEN_BL8  WEN_BL9  WEN_BL10 WEN_BL11 WEN_BL12 WEN_BL13 WEN_BL14 WEN_BL15
+ WEN_BL16 WEN_BL17 WEN_BL18 WEN_BL19 WEN_BL20 WEN_BL21 WEN_BL22 WEN_BL23
+ WEN_BL24 WEN_BL25 WEN_BL26 WEN_BL27 WEN_BL28 WEN_BL29 WEN_BL30 WEN_BL31
+ WEN_BLB0 WEN_BLB1 WEN_BLB2 WEN_BLB3 WEN_BLB4 WEN_BLB5 WEN_BLB6 WEN_BLB7
+ WEN_BLB8 WEN_BLB9 WEN_BLB10 WEN_BLB11 WEN_BLB12 WEN_BLB13 WEN_BLB14 WEN_BLB15
+ WEN_BLB16 WEN_BLB17 WEN_BLB18 WEN_BLB19 WEN_BLB20 WEN_BLB21 WEN_BLB22 WEN_BLB23
+ WEN_BLB24 WEN_BLB25 WEN_BLB26 WEN_BLB27 WEN_BLB28 WEN_BLB29 WEN_BLB30 WEN_BLB31
+ VDD VSS VSS_SUB
+ VDD_W0 VDD_W1 VDD_W2 VDD_W3 VDD_W4

Xdec IN A0_b A0 VDD VSS VDD_W1 VSS_SUB DEC_1to2
Xinv1 A0   A1_b VDD VSS VDD_W2 VSS_SUB INV_c
Xinv2 A0_b A1   VDD VSS VDD_W2 VSS_SUB INV_c
Xinv3 A1   A2_b VDD VSS VDD_W2 VSS_SUB INV_c
Xinv4 A1_b A2   VDD VSS VDD_W2 VSS_SUB INV_c
Xinv5 A2   A3_b VDD VSS VDD_W3 VSS_SUB INV_c
Xinv6 A2_b A3   VDD VSS VDD_W3 VSS_SUB INV_c

Xinv_en1  WEN    WEN_b0 VDD VSS VDD_W1 VSS_SUB INV_c
Xinv_en2  WEN_b0 WEN1   VDD VSS VDD_W3 VSS_SUB INV_c
Xinv_en3  WEN1   WEN_b1 VDD VSS VDD_W3 VSS_SUB INV_c

X_slice0  WEN_b0 A0   A0_b   D0  WEN_BL0  WEN_BLB0  WEN_BL16 WEN_BLB16
+ VDD VSS VDD_W1 VDD_W0 VSS_SUB bl_to_wen_slice
X_slice1  WEN_b0 A0   A0_b   D1  WEN_BL1  WEN_BLB1  WEN_BL17 WEN_BLB17
+ VDD VSS VDD_W1 VDD_W0 VSS_SUB bl_to_wen_slice
X_slice2  WEN_b0 A0   A0_b   D2  WEN_BL2  WEN_BLB2  WEN_BL18 WEN_BLB18
+ VDD VSS VDD_W1 VDD_W0 VSS_SUB bl_to_wen_slice
X_slice3  WEN_b0 A0   A0_b   D3  WEN_BL3  WEN_BLB3  WEN_BL19 WEN_BLB19
+ VDD VSS VDD_W1 VDD_W0 VSS_SUB bl_to_wen_slice

X_slice4  WEN_b0 A1   A1_b   D4  WEN_BL4  WEN_BLB4  WEN_BL20 WEN_BLB20
+ VDD VSS VDD_W1 VDD_W2 VSS_SUB bl_to_wen_slice
X_slice5  WEN_b0 A1   A1_b   D5  WEN_BL5  WEN_BLB5  WEN_BL21 WEN_BLB21
+ VDD VSS VDD_W1 VDD_W2 VSS_SUB bl_to_wen_slice
X_slice6  WEN_b0 A1   A1_b   D6  WEN_BL6  WEN_BLB6  WEN_BL22 WEN_BLB22
+ VDD VSS VDD_W1 VDD_W2 VSS_SUB bl_to_wen_slice
X_slice7  WEN_b0 A1   A1_b   D7  WEN_BL7  WEN_BLB7  WEN_BL23 WEN_BLB23
+ VDD VSS VDD_W1 VDD_W2 VSS_SUB bl_to_wen_slice

X_slice8  WEN_b1 A2   A2_b   D8  WEN_BL8  WEN_BLB8  WEN_BL24 WEN_BLB24
+ VDD VSS VDD_W3 VDD_W2 VSS_SUB bl_to_wen_slice
X_slice9  WEN_b1 A2   A2_b   D9  WEN_BL9  WEN_BLB9  WEN_BL25 WEN_BLB25
+ VDD VSS VDD_W3 VDD_W2 VSS_SUB bl_to_wen_slice
X_slice10 WEN_b1 A2   A2_b   D10 WEN_BL10 WEN_BLB10 WEN_BL26 WEN_BLB26
+ VDD VSS VDD_W3 VDD_W2 VSS_SUB bl_to_wen_slice
X_slice11 WEN_b1 A2   A2_b   D11 WEN_BL11 WEN_BLB11 WEN_BL27 WEN_BLB27
+ VDD VSS VDD_W3 VDD_W2 VSS_SUB bl_to_wen_slice

X_slice12 WEN_b1 A3   A3_b   D12 WEN_BL12 WEN_BLB12 WEN_BL28 WEN_BLB28
+ VDD VSS VDD_W3 VDD_W4 VSS_SUB bl_to_wen_slice
X_slice13 WEN_b1 A3   A3_b   D13 WEN_BL13 WEN_BLB13 WEN_BL29 WEN_BLB29
+ VDD VSS VDD_W3 VDD_W4 VSS_SUB bl_to_wen_slice
X_slice14 WEN_b1 A3   A3_b   D14 WEN_BL14 WEN_BLB14 WEN_BL30 WEN_BLB30
+ VDD VSS VDD_W3 VDD_W4 VSS_SUB bl_to_wen_slice
X_slice15 WEN_b1 A3   A3_b   D15 WEN_BL15 WEN_BLB15 WEN_BL31 WEN_BLB31
+ VDD VSS VDD_W3 VDD_W4 VSS_SUB bl_to_wen_slice
.ends

* ------ 3. 基礎邏輯閘子電路(column selector) ------
.subckt SEL select OUT1 OUT2 IN1 IN2 VSS_SUB
Mn1 IN1 select OUT1 VSS_SUB nmos_lvt W=5.4e-08 L=2e-08 nfin=2
Mn2 IN2 select OUT2 VSS_SUB nmos_lvt W=5.4e-08 L=2e-08 nfin=2
.ends

* ------ 4. 主 column mutiplexer 核心 ------
.subckt COL_SEL IN WEN
+ Q0  Q1  Q2  Q3  Q4  Q5  Q6  Q7
+ Q8  Q9  Q10 Q11 Q12 Q13 Q14 Q15
+ QB0  QB1  QB2  QB3  QB4  QB5  QB6  QB7
+ QB8  QB9  QB10 QB11 QB12 QB13 QB14 QB15
+ SENSE_OUT0  SENSE_OUT1  SENSE_OUT2  SENSE_OUT3  SENSE_OUT4  SENSE_OUT5  SENSE_OUT6  SENSE_OUT7
+ SENSE_OUT8  SENSE_OUT9  SENSE_OUT10 SENSE_OUT11 SENSE_OUT12 SENSE_OUT13 SENSE_OUT14 SENSE_OUT15
+ SENSE_OUT16 SENSE_OUT17 SENSE_OUT18 SENSE_OUT19 SENSE_OUT20 SENSE_OUT21 SENSE_OUT22 SENSE_OUT23
+ SENSE_OUT24 SENSE_OUT25 SENSE_OUT26 SENSE_OUT27 SENSE_OUT28 SENSE_OUT29 SENSE_OUT30 SENSE_OUT31
+ SENSE_OUTB0  SENSE_OUTB1  SENSE_OUTB2  SENSE_OUTB3  SENSE_OUTB4  SENSE_OUTB5  SENSE_OUTB6  SENSE_OUTB7
+ SENSE_OUTB8  SENSE_OUTB9  SENSE_OUTB10 SENSE_OUTB11 SENSE_OUTB12 SENSE_OUTB13 SENSE_OUTB14 SENSE_OUTB15
+ SENSE_OUTB16 SENSE_OUTB17 SENSE_OUTB18 SENSE_OUTB19 SENSE_OUTB20 SENSE_OUTB21 SENSE_OUTB22 SENSE_OUTB23
+ SENSE_OUTB24 SENSE_OUTB25 SENSE_OUTB26 SENSE_OUTB27 SENSE_OUTB28 SENSE_OUTB29 SENSE_OUTB30 SENSE_OUTB31
+ VDD VSS VDD_W0 VDD_W1 VSS_SUB

Xand    WEN    IN     select VDD VSS VDD_W0 VSS_SUB AND2_c
Xdec    select sel0_0 sel0_1 VDD VSS VDD_W0 VSS_SUB DEC_1to2

Xinv0 sel0_0 sel1_1 VDD VSS VDD_W1 VSS_SUB INV_c
Xinv1 sel0_1 sel1_0 VDD VSS VDD_W1 VSS_SUB INV_c
Xinv3 sel1_0 sel2_1 VDD VSS VDD_W1 VSS_SUB INV_c
Xinv4 sel1_1 sel2_0 VDD VSS VDD_W1 VSS_SUB INV_c
Xinv5 sel2_0 sel3_1 VDD VSS VDD_W0 VSS_SUB INV_c
Xinv6 sel2_1 sel3_0 VDD VSS VDD_W0 VSS_SUB INV_c

Xsel0  sel0_0 Q0  QB0  SENSE_OUT0  SENSE_OUTB0  VSS_SUB  SEL
Xsel2  sel0_0 Q1  QB1  SENSE_OUT1  SENSE_OUTB1  VSS_SUB  SEL
Xsel4  sel0_0 Q2  QB2  SENSE_OUT2  SENSE_OUTB2  VSS_SUB  SEL
Xsel6  sel0_0 Q3  QB3  SENSE_OUT3  SENSE_OUTB3  VSS_SUB  SEL

Xsel8  sel1_0 Q4  QB4  SENSE_OUT4  SENSE_OUTB4  VSS_SUB  SEL
Xsel10 sel1_0 Q5  QB5  SENSE_OUT5  SENSE_OUTB5  VSS_SUB  SEL
Xsel12 sel1_0 Q6  QB6  SENSE_OUT6  SENSE_OUTB6  VSS_SUB  SEL
Xsel14 sel1_0 Q7  QB7  SENSE_OUT7  SENSE_OUTB7  VSS_SUB  SEL

Xsel16 sel2_0 Q8  QB8  SENSE_OUT8  SENSE_OUTB8  VSS_SUB  SEL
Xsel18 sel2_0 Q9  QB9  SENSE_OUT9  SENSE_OUTB9  VSS_SUB  SEL
Xsel20 sel2_0 Q10 QB10 SENSE_OUT10 SENSE_OUTB10 VSS_SUB  SEL
Xsel22 sel2_0 Q11 QB11 SENSE_OUT11 SENSE_OUTB11 VSS_SUB  SEL

Xsel24 sel3_0 Q12 QB12 SENSE_OUT12 SENSE_OUTB12 VSS_SUB  SEL
Xsel26 sel3_0 Q13 QB13 SENSE_OUT13 SENSE_OUTB13 VSS_SUB  SEL
Xsel28 sel3_0 Q14 QB14 SENSE_OUT14 SENSE_OUTB14 VSS_SUB  SEL
Xsel30 sel3_0 Q15 QB15 SENSE_OUT15 SENSE_OUTB15 VSS_SUB  SEL

Xsel1  sel0_1 Q0  QB0  SENSE_OUT16 SENSE_OUTB16 VSS_SUB  SEL
Xsel3  sel0_1 Q1  QB1  SENSE_OUT17 SENSE_OUTB17 VSS_SUB  SEL
Xsel5  sel0_1 Q2  QB2  SENSE_OUT18 SENSE_OUTB18 VSS_SUB  SEL
Xsel7  sel0_1 Q3  QB3  SENSE_OUT19 SENSE_OUTB19 VSS_SUB  SEL

Xsel9  sel1_1 Q4  QB4  SENSE_OUT20 SENSE_OUTB20 VSS_SUB  SEL
Xsel11 sel1_1 Q5  QB5  SENSE_OUT21 SENSE_OUTB21 VSS_SUB  SEL
Xsel13 sel1_1 Q6  QB6  SENSE_OUT22 SENSE_OUTB22 VSS_SUB  SEL
Xsel15 sel1_1 Q7  QB7  SENSE_OUT23 SENSE_OUTB23 VSS_SUB  SEL

Xsel17 sel2_1 Q8  QB8  SENSE_OUT24 SENSE_OUTB24 VSS_SUB  SEL
Xsel19 sel2_1 Q9  QB9  SENSE_OUT25 SENSE_OUTB25 VSS_SUB  SEL
Xsel21 sel2_1 Q10 QB10 SENSE_OUT26 SENSE_OUTB26 VSS_SUB  SEL
Xsel23 sel2_1 Q11 QB11 SENSE_OUT27 SENSE_OUTB27 VSS_SUB  SEL

Xsel25 sel3_1 Q12 QB12 SENSE_OUT28 SENSE_OUTB28 VSS_SUB  SEL
Xsel27 sel3_1 Q13 QB13 SENSE_OUT29 SENSE_OUTB29 VSS_SUB  SEL
Xsel29 sel3_1 Q14 QB14 SENSE_OUT30 SENSE_OUTB30 VSS_SUB  SEL
Xsel31 sel3_1 Q15 QB15 SENSE_OUT31 SENSE_OUTB31 VSS_SUB  SEL
.ends
