.title Read Write 64x32 SRAM Array Simulation
*****************************
**     Library setting     **
*****************************
.protect
.include '7nm_TT.pm'
.unprotect
.include '6to64_row_decoder.sp'
.include 'SRAM_array_64x32.sp'
.include 'column_based_circuit.sp'
.include 'DFF.sp'

*****************************
**   Circuit Description   **
*****************************
xdff_a0 CLK A0 A0q DFF
xdff_a1 CLK A1 A1q DFF
xdff_a2 CLK A2 A2q DFF
xdff_a3 CLK A3 A3q DFF
xdff_a4 CLK A4 A4q DFF
xdff_a5 CLK A5 A5q DFF
xdff_a6 CLK A6 A6q DFF
xdff_d0 CLK D0 D0q DFF
xdff_d1 CLK D1 D1q DFF
xdff_d2 CLK D2 D2q DFF
xdff_d3 CLK D3 D3q DFF
xdff_d4 CLK D4 D4q DFF
xdff_d5 CLK D5 D5q DFF
xdff_d6 CLK D6 D6q DFF
xdff_d7 CLK D7 D7q DFF
xdff_d8 CLK D8 D8q DFF
xdff_d9 CLK D9 D9q DFF
xdff_d10 CLK D10 D10q DFF
xdff_d11 CLK D11 D11q DFF
xdff_d12 CLK D12 D12q DFF
xdff_d13 CLK D13 D13q DFF
xdff_d14 CLK D14 D14q DFF
xdff_d15 CLK D15 D15q DFF
xdff_wen CLK WEN WENq DFF

* 呼叫 Row Decoder (注意：引腳順序必須跟上面定義的完全一模一樣)
xdecoder A6q A5q A4q A3q A2q A1q
+ WL0 WL1 WL2 WL3 WL4 WL5 WL6 WL7 WL8 WL9 WL10 WL11 WL12 WL13 WL14 WL15
+ WL16 WL17 WL18 WL19 WL20 WL21 WL22 WL23 WL24 WL25 WL26 WL27 WL28 WL29 WL30 WL31
+ WL32 WL33 WL34 WL35 WL36 WL37 WL38 WL39 WL40 WL41 WL42 WL43 WL44 WL45 WL46 WL47
+ WL48 WL49 WL50 WL51 WL52 WL53 WL54 WL55 WL56 WL57 WL58 WL59 WL60 WL61 WL62 WL63
+ ROW_DEC_6to64

XARRAY_TOP PRE SAEN VDD GND
+ WL0 WL1 WL2 WL3 WL4 WL5 WL6 WL7 WL8 WL9 WL10 WL11 WL12 WL13 WL14 WL15
+ WL16 WL17 WL18 WL19 WL20 WL21 WL22 WL23 WL24 WL25 WL26 WL27 WL28 WL29 WL30 WL31
+ WL32 WL33 WL34 WL35 WL36 WL37 WL38 WL39 WL40 WL41 WL42 WL43 WL44 WL45 WL46 WL47
+ WL48 WL49 WL50 WL51 WL52 WL53 WL54 WL55 WL56 WL57 WL58 WL59 WL60 WL61 WL62 WL63
+ SENSE_OUT0 SENSE_OUTB0 WEN_BL0 WEN_BLB0
+ SENSE_OUT1 SENSE_OUTB1 WEN_BL1 WEN_BLB1
+ SENSE_OUT2 SENSE_OUTB2 WEN_BL2 WEN_BLB2
+ SENSE_OUT3 SENSE_OUTB3 WEN_BL3 WEN_BLB3
+ SENSE_OUT4 SENSE_OUTB4 WEN_BL4 WEN_BLB4
+ SENSE_OUT5 SENSE_OUTB5 WEN_BL5 WEN_BLB5
+ SENSE_OUT6 SENSE_OUTB6 WEN_BL6 WEN_BLB6
+ SENSE_OUT7 SENSE_OUTB7 WEN_BL7 WEN_BLB7
+ SENSE_OUT8 SENSE_OUTB8 WEN_BL8 WEN_BLB8
+ SENSE_OUT9 SENSE_OUTB9 WEN_BL9 WEN_BLB9
+ SENSE_OUT10 SENSE_OUTB10 WEN_BL10 WEN_BLB10
+ SENSE_OUT11 SENSE_OUTB11 WEN_BL11 WEN_BLB11
+ SENSE_OUT12 SENSE_OUTB12 WEN_BL12 WEN_BLB12
+ SENSE_OUT13 SENSE_OUTB13 WEN_BL13 WEN_BLB13
+ SENSE_OUT14 SENSE_OUTB14 WEN_BL14 WEN_BLB14
+ SENSE_OUT15 SENSE_OUTB15 WEN_BL15 WEN_BLB15
+ SENSE_OUT16 SENSE_OUTB16 WEN_BL16 WEN_BLB16
+ SENSE_OUT17 SENSE_OUTB17 WEN_BL17 WEN_BLB17
+ SENSE_OUT18 SENSE_OUTB18 WEN_BL18 WEN_BLB18
+ SENSE_OUT19 SENSE_OUTB19 WEN_BL19 WEN_BLB19
+ SENSE_OUT20 SENSE_OUTB20 WEN_BL20 WEN_BLB20
+ SENSE_OUT21 SENSE_OUTB21 WEN_BL21 WEN_BLB21
+ SENSE_OUT22 SENSE_OUTB22 WEN_BL22 WEN_BLB22
+ SENSE_OUT23 SENSE_OUTB23 WEN_BL23 WEN_BLB23
+ SENSE_OUT24 SENSE_OUTB24 WEN_BL24 WEN_BLB24
+ SENSE_OUT25 SENSE_OUTB25 WEN_BL25 WEN_BLB25
+ SENSE_OUT26 SENSE_OUTB26 WEN_BL26 WEN_BLB26
+ SENSE_OUT27 SENSE_OUTB27 WEN_BL27 WEN_BLB27
+ SENSE_OUT28 SENSE_OUTB28 WEN_BL28 WEN_BLB28
+ SENSE_OUT29 SENSE_OUTB29 WEN_BL29 WEN_BLB29
+ SENSE_OUT30 SENSE_OUTB30 WEN_BL30 WEN_BLB30
+ SENSE_OUT31 SENSE_OUTB31 WEN_BL31 WEN_BLB31
+ SRAM_Array_64x32

Xcol_driver_array_w A0q WENq
+ D0q D1q D2q D3q D4q D5q D6q D7q
+ D8q D9q D10q D11q D12q D13q D14q D15q
+ WEN_BL0 WEN_BL1 WEN_BL2 WEN_BL3 WEN_BL4 WEN_BL5 WEN_BL6 WEN_BL7
+ WEN_BL8 WEN_BL9 WEN_BL10 WEN_BL11 WEN_BL12 WEN_BL13 WEN_BL14 WEN_BL15
+ WEN_BL16 WEN_BL17 WEN_BL18 WEN_BL19 WEN_BL20 WEN_BL21 WEN_BL22 WEN_BL23
+ WEN_BL24 WEN_BL25 WEN_BL26 WEN_BL27 WEN_BL28 WEN_BL29 WEN_BL30 WEN_BL31
+ WEN_BLB0 WEN_BLB1 WEN_BLB2 WEN_BLB3 WEN_BLB4 WEN_BLB5 WEN_BLB6 WEN_BLB7
+ WEN_BLB8 WEN_BLB9 WEN_BLB10 WEN_BLB11 WEN_BLB12 WEN_BLB13 WEN_BLB14 WEN_BLB15
+ WEN_BLB16 WEN_BLB17 WEN_BLB18 WEN_BLB19 WEN_BLB20 WEN_BLB21 WEN_BLB22 WEN_BLB23
+ WEN_BLB24 WEN_BLB25 WEN_BLB26 WEN_BLB27 WEN_BLB28 WEN_BLB29 WEN_BLB30 WEN_BLB31
+ COL_DRIVER_ARRAY

Xcol_selector_r A0q WENq
+ Q0 Q1 Q2 Q3 Q4 Q5 Q6 Q7
+ Q8 Q9 Q10 Q11 Q12 Q13 Q14 Q15
+ QB0 QB1 QB2 QB3 QB4 QB5 QB6 QB7
+ QB8 QB9 QB10 QB11 QB12 QB13 QB14 QB15
+ SENSE_OUT0 SENSE_OUT1 SENSE_OUT2 SENSE_OUT3 SENSE_OUT4 SENSE_OUT5 SENSE_OUT6 SENSE_OUT7
+ SENSE_OUT8 SENSE_OUT9 SENSE_OUT10 SENSE_OUT11 SENSE_OUT12 SENSE_OUT13 SENSE_OUT14 SENSE_OUT15
+ SENSE_OUT16 SENSE_OUT17 SENSE_OUT18 SENSE_OUT19 SENSE_OUT20 SENSE_OUT21 SENSE_OUT22 SENSE_OUT23
+ SENSE_OUT24 SENSE_OUT25 SENSE_OUT26 SENSE_OUT27 SENSE_OUT28 SENSE_OUT29 SENSE_OUT30 SENSE_OUT31
+ SENSE_OUTB0 SENSE_OUTB1 SENSE_OUTB2 SENSE_OUTB3 SENSE_OUTB4 SENSE_OUTB5 SENSE_OUTB6 SENSE_OUTB7
+ SENSE_OUTB8 SENSE_OUTB9 SENSE_OUTB10 SENSE_OUTB11 SENSE_OUTB12 SENSE_OUTB13 SENSE_OUTB14 SENSE_OUTB15
+ SENSE_OUTB16 SENSE_OUTB17 SENSE_OUTB18 SENSE_OUTB19 SENSE_OUTB20 SENSE_OUTB21 SENSE_OUTB22 SENSE_OUTB23
+ SENSE_OUTB24 SENSE_OUTB25 SENSE_OUTB26 SENSE_OUTB27 SENSE_OUTB28 SENSE_OUTB29 SENSE_OUTB30 SENSE_OUTB31
+ COL_SEL

*****************************
**     Voltage Source      **
*****************************
* Do not modify below *
.global VDD GND
.param  BITCAP = 10f

VVDD VDD GND 0.7v

*CBLB BLB GND BITCAP
*CBL  BL  GND BITCAP

Vc CLK GND PULSE(0V 0.700V 4.000ns 0.050ns 0.050ns 0.450ns 1.000ns)

Vp PRE GND PULSE(0V 0.700V 4.000ns 0.050ns 0.050ns 0.350ns 1.000ns)

Vs SAEN GND PWL(0ns 0V 5.250ns 0V 5.300ns 0.700V 5.400ns 0.700V 5.450ns 0V 7.250ns 0V 7.300ns 0.700V 7.400ns 0.700V 7.450ns 0V 9.250ns 0V 9.300ns 0.700V 9.400ns 0.700V 9.450ns 0V 11.250ns 0V 11.300ns 0.700V 11.400ns 0.700V 11.450ns 0V 13.250ns 0V 13.300ns 0.700V 13.400ns 0.700V 13.450ns 0V 15.250ns 0V 15.300ns 0.700V 15.400ns 0.700V 15.450ns 0V 17.250ns 0V 17.300ns 0.700V 17.400ns 0.700V 17.450ns 0V 19.250ns 0V 19.300ns 0.700V 19.400ns 0.700V 19.450ns 0V 21.250ns 0V 21.300ns 0.700V 21.400ns 0.700V 21.450ns 0V 23.250ns 0V 23.300ns 0.700V 23.400ns 0.700V 23.450ns 0V 25.250ns 0V 25.300ns 0.700V 25.400ns 0.700V 25.450ns 0V 27.250ns 0V 27.300ns 0.700V 27.400ns 0.700V 27.450ns 0V 29.250ns 0V 29.300ns 0.700V 29.400ns 0.700V 29.450ns 0V 31.250ns 0V 31.300ns 0.700V 31.400ns 0.700V 31.450ns 0V 33.250ns 0V 33.300ns 0.700V 33.400ns 0.700V 33.450ns 0V 35.250ns 0V 35.300ns 0.700V 35.400ns 0.700V 35.450ns 0V 37.250ns 0V 37.300ns 0.700V 37.400ns 0.700V 37.450ns 0V 39.250ns 0V 39.300ns 0.700V 39.400ns 0.700V 39.450ns 0V 41.250ns 0V 41.300ns 0.700V 41.400ns 0.700V 41.450ns 0V 43.250ns 0V 43.300ns 0.700V 43.400ns 0.700V 43.450ns 0V 45.250ns 0V 45.300ns 0.700V 45.400ns 0.700V 45.450ns 0V 47.250ns 0V 47.300ns 0.700V 47.400ns 0.700V 47.450ns 0V 49.250ns 0V 49.300ns 0.700V 49.400ns 0.700V 49.450ns 0V 51.250ns 0V 51.300ns 0.700V 51.400ns 0.700V 51.450ns 0V 53.250ns 0V 53.300ns 0.700V 53.400ns 0.700V 53.450ns 0V 55.250ns 0V 55.300ns 0.700V 55.400ns 0.700V 55.450ns 0V 57.250ns 0V 57.300ns 0.700V 57.400ns 0.700V 57.450ns 0V 59.250ns 0V 59.300ns 0.700V 59.400ns 0.700V 59.450ns 0V 61.250ns 0V 61.300ns 0.700V 61.400ns 0.700V 61.450ns 0V 63.250ns 0V 63.300ns 0.700V 63.400ns 0.700V 63.450ns 0V 65.250ns 0V 65.300ns 0.700V 65.400ns 0.700V 65.450ns 0V 67.250ns 0V 67.300ns 0.700V 67.400ns 0.700V 67.450ns 0V 69.250ns 0V 69.300ns 0.700V 69.400ns 0.700V 69.450ns 0V 71.250ns 0V 71.300ns 0.700V 71.400ns 0.700V 71.450ns 0V 73.250ns 0V 73.300ns 0.700V 73.400ns 0.700V 73.450ns 0V 75.250ns 0V 75.300ns 0.700V 75.400ns 0.700V 75.450ns 0V 77.250ns 0V 77.300ns 0.700V 77.400ns 0.700V 77.450ns 0V 79.250ns 0V 79.300ns 0.700V 79.400ns 0.700V 79.450ns 0V 81.250ns 0V 81.300ns 0.700V 81.400ns 0.700V 81.450ns 0V 83.250ns 0V 83.300ns 0.700V 83.400ns 0.700V 83.450ns 0V 85.250ns 0V 85.300ns 0.700V 85.400ns 0.700V 85.450ns 0V 87.250ns 0V 87.300ns 0.700V 87.400ns 0.700V 87.450ns 0V 89.250ns 0V 89.300ns 0.700V 89.400ns 0.700V 89.450ns 0V 91.250ns 0V 91.300ns 0.700V 91.400ns 0.700V 91.450ns 0V 93.250ns 0V 93.300ns 0.700V 93.400ns 0.700V 93.450ns 0V 95.250ns 0V 95.300ns 0.700V 95.400ns 0.700V 95.450ns 0V 97.250ns 0V 97.300ns 0.700V 97.400ns 0.700V 97.450ns 0V 99.250ns 0V 99.300ns 0.700V 99.400ns 0.700V 99.450ns 0V 101.250ns 0V 101.300ns 0.700V 101.400ns 0.700V 101.450ns 0V 103.250ns 0V 103.300ns 0.700V 103.400ns 0.700V 103.450ns 0V 105.250ns 0V 105.300ns 0.700V 105.400ns 0.700V 105.450ns 0V 107.250ns 0V 107.300ns 0.700V 107.400ns 0.700V 107.450ns 0V 109.250ns 0V 109.300ns 0.700V 109.400ns 0.700V 109.450ns 0V 111.250ns 0V 111.300ns 0.700V 111.400ns 0.700V 111.450ns 0V 113.250ns 0V 113.300ns 0.700V 113.400ns 0.700V 113.450ns 0V 115.250ns 0V 115.300ns 0.700V 115.400ns 0.700V 115.450ns 0V 117.250ns 0V 117.300ns 0.700V 117.400ns 0.700V 117.450ns 0V 119.250ns 0V 119.300ns 0.700V 119.400ns 0.700V 119.450ns 0V 121.250ns 0V 121.300ns 0.700V 121.400ns 0.700V 121.450ns 0V 123.250ns 0V 123.300ns 0.700V 123.400ns 0.700V 123.450ns 0V 125.250ns 0V 125.300ns 0.700V 125.400ns 0.700V 125.450ns 0V 127.250ns 0V 127.300ns 0.700V 127.400ns 0.700V 127.450ns 0V 129.250ns 0V 129.300ns 0.700V 129.400ns 0.700V 129.450ns 0V 131.250ns 0V 131.300ns 0.700V 131.400ns 0.700V 131.450ns 0V)

Vw WEN GND PWL(0ns 0.000V 4.100ns 0.000V 4.150ns 0.700V 5.100ns 0.700V 5.150ns 0.000V 6.100ns 0.000V 6.150ns 0.700V 7.100ns 0.700V 7.150ns 0.000V 8.100ns 0.000V 8.150ns 0.700V 9.100ns 0.700V 9.150ns 0.000V 10.100ns 0.000V 10.150ns 0.700V 11.100ns 0.700V 11.150ns 0.000V 12.100ns 0.000V 12.150ns 0.700V 13.100ns 0.700V 13.150ns 0.000V 14.100ns 0.000V 14.150ns 0.700V 15.100ns 0.700V 15.150ns 0.000V 16.100ns 0.000V 16.150ns 0.700V 17.100ns 0.700V 17.150ns 0.000V 18.100ns 0.000V 18.150ns 0.700V 19.100ns 0.700V 19.150ns 0.000V 20.100ns 0.000V 20.150ns 0.700V 21.100ns 0.700V 21.150ns 0.000V 22.100ns 0.000V 22.150ns 0.700V 23.100ns 0.700V 23.150ns 0.000V 24.100ns 0.000V 24.150ns 0.700V 25.100ns 0.700V 25.150ns 0.000V 26.100ns 0.000V 26.150ns 0.700V 27.100ns 0.700V 27.150ns 0.000V 28.100ns 0.000V 28.150ns 0.700V 29.100ns 0.700V 29.150ns 0.000V 30.100ns 0.000V 30.150ns 0.700V 31.100ns 0.700V 31.150ns 0.000V 32.100ns 0.000V 32.150ns 0.700V 33.100ns 0.700V 33.150ns 0.000V 34.100ns 0.000V 34.150ns 0.700V 35.100ns 0.700V 35.150ns 0.000V 36.100ns 0.000V 36.150ns 0.700V 37.100ns 0.700V 37.150ns 0.000V 38.100ns 0.000V 38.150ns 0.700V 39.100ns 0.700V 39.150ns 0.000V 40.100ns 0.000V 40.150ns 0.700V 41.100ns 0.700V 41.150ns 0.000V 42.100ns 0.000V 42.150ns 0.700V 43.100ns 0.700V 43.150ns 0.000V 44.100ns 0.000V 44.150ns 0.700V 45.100ns 0.700V 45.150ns 0.000V 46.100ns 0.000V 46.150ns 0.700V 47.100ns 0.700V 47.150ns 0.000V 48.100ns 0.000V 48.150ns 0.700V 49.100ns 0.700V 49.150ns 0.000V 50.100ns 0.000V 50.150ns 0.700V 51.100ns 0.700V 51.150ns 0.000V 52.100ns 0.000V 52.150ns 0.700V 53.100ns 0.700V 53.150ns 0.000V 54.100ns 0.000V 54.150ns 0.700V 55.100ns 0.700V 55.150ns 0.000V 56.100ns 0.000V 56.150ns 0.700V 57.100ns 0.700V 57.150ns 0.000V 58.100ns 0.000V 58.150ns 0.700V 59.100ns 0.700V 59.150ns 0.000V 60.100ns 0.000V 60.150ns 0.700V 61.100ns 0.700V 61.150ns 0.000V 62.100ns 0.000V 62.150ns 0.700V 63.100ns 0.700V 63.150ns 0.000V 64.100ns 0.000V 64.150ns 0.700V 65.100ns 0.700V 65.150ns 0.000V 66.100ns 0.000V 66.150ns 0.700V 67.100ns 0.700V 67.150ns 0.000V 68.100ns 0.000V 68.150ns 0.700V 69.100ns 0.700V 69.150ns 0.000V 70.100ns 0.000V 70.150ns 0.700V 71.100ns 0.700V 71.150ns 0.000V 72.100ns 0.000V 72.150ns 0.700V 73.100ns 0.700V 73.150ns 0.000V 74.100ns 0.000V 74.150ns 0.700V 75.100ns 0.700V 75.150ns 0.000V 76.100ns 0.000V 76.150ns 0.700V 77.100ns 0.700V 77.150ns 0.000V 78.100ns 0.000V 78.150ns 0.700V 79.100ns 0.700V 79.150ns 0.000V 80.100ns 0.000V 80.150ns 0.700V 81.100ns 0.700V 81.150ns 0.000V 82.100ns 0.000V 82.150ns 0.700V 83.100ns 0.700V 83.150ns 0.000V 84.100ns 0.000V 84.150ns 0.700V 85.100ns 0.700V 85.150ns 0.000V 86.100ns 0.000V 86.150ns 0.700V 87.100ns 0.700V 87.150ns 0.000V 88.100ns 0.000V 88.150ns 0.700V 89.100ns 0.700V 89.150ns 0.000V 90.100ns 0.000V 90.150ns 0.700V 91.100ns 0.700V 91.150ns 0.000V 92.100ns 0.000V 92.150ns 0.700V 93.100ns 0.700V 93.150ns 0.000V 94.100ns 0.000V 94.150ns 0.700V 95.100ns 0.700V 95.150ns 0.000V 96.100ns 0.000V 96.150ns 0.700V 97.100ns 0.700V 97.150ns 0.000V 98.100ns 0.000V 98.150ns 0.700V 99.100ns 0.700V 99.150ns 0.000V 100.100ns 0.000V 100.150ns 0.700V 101.100ns 0.700V 101.150ns 0.000V 102.100ns 0.000V 102.150ns 0.700V 103.100ns 0.700V 103.150ns 0.000V 104.100ns 0.000V 104.150ns 0.700V 105.100ns 0.700V 105.150ns 0.000V 106.100ns 0.000V 106.150ns 0.700V 107.100ns 0.700V 107.150ns 0.000V 108.100ns 0.000V 108.150ns 0.700V 109.100ns 0.700V 109.150ns 0.000V 110.100ns 0.000V 110.150ns 0.700V 111.100ns 0.700V 111.150ns 0.000V 112.100ns 0.000V 112.150ns 0.700V 113.100ns 0.700V 113.150ns 0.000V 114.100ns 0.000V 114.150ns 0.700V 115.100ns 0.700V 115.150ns 0.000V 116.100ns 0.000V 116.150ns 0.700V 117.100ns 0.700V 117.150ns 0.000V 118.100ns 0.000V 118.150ns 0.700V 119.100ns 0.700V 119.150ns 0.000V 120.100ns 0.000V 120.150ns 0.700V 121.100ns 0.700V 121.150ns 0.000V 122.100ns 0.000V 122.150ns 0.700V 123.100ns 0.700V 123.150ns 0.000V 124.100ns 0.000V 124.150ns 0.700V 125.100ns 0.700V 125.150ns 0.000V 126.100ns 0.000V 126.150ns 0.700V 127.100ns 0.700V 127.150ns 0.000V 128.100ns 0.000V 128.150ns 0.700V 129.100ns 0.700V 129.150ns 0.000V 130.100ns 0.000V 130.150ns 0.700V)

VA0 A0 GND PWL(0ns 0.000V 5.100ns 0.000V 5.150ns 0.700V 7.100ns 0.700V 7.150ns 0.000V 9.100ns 0.000V 9.150ns 0.700V 11.100ns 0.700V 11.150ns 0.000V 13.100ns 0.000V 13.150ns 0.700V 15.100ns 0.700V 15.150ns 0.000V 17.100ns 0.000V 17.150ns 0.700V 19.100ns 0.700V 19.150ns 0.000V 21.100ns 0.000V 21.150ns 0.700V 23.100ns 0.700V 23.150ns 0.000V 25.100ns 0.000V 25.150ns 0.700V 27.100ns 0.700V 27.150ns 0.000V 29.100ns 0.000V 29.150ns 0.700V 31.100ns 0.700V 31.150ns 0.000V 33.100ns 0.000V 33.150ns 0.700V 35.100ns 0.700V 35.150ns 0.000V 37.100ns 0.000V 37.150ns 0.700V 39.100ns 0.700V 39.150ns 0.000V 41.100ns 0.000V 41.150ns 0.700V 43.100ns 0.700V 43.150ns 0.000V 45.100ns 0.000V 45.150ns 0.700V 47.100ns 0.700V 47.150ns 0.000V 49.100ns 0.000V 49.150ns 0.700V 51.100ns 0.700V 51.150ns 0.000V 53.100ns 0.000V 53.150ns 0.700V 55.100ns 0.700V 55.150ns 0.000V 57.100ns 0.000V 57.150ns 0.700V 59.100ns 0.700V 59.150ns 0.000V 61.100ns 0.000V 61.150ns 0.700V 63.100ns 0.700V 63.150ns 0.000V 65.100ns 0.000V 65.150ns 0.700V 67.100ns 0.700V 67.150ns 0.000V 69.100ns 0.000V 69.150ns 0.700V 71.100ns 0.700V 71.150ns 0.000V 73.100ns 0.000V 73.150ns 0.700V 75.100ns 0.700V 75.150ns 0.000V 77.100ns 0.000V 77.150ns 0.700V 79.100ns 0.700V 79.150ns 0.000V 81.100ns 0.000V 81.150ns 0.700V 83.100ns 0.700V 83.150ns 0.000V 85.100ns 0.000V 85.150ns 0.700V 87.100ns 0.700V 87.150ns 0.000V 89.100ns 0.000V 89.150ns 0.700V 91.100ns 0.700V 91.150ns 0.000V 93.100ns 0.000V 93.150ns 0.700V 95.100ns 0.700V 95.150ns 0.000V 97.100ns 0.000V 97.150ns 0.700V 99.100ns 0.700V 99.150ns 0.000V 101.100ns 0.000V 101.150ns 0.700V 103.100ns 0.700V 103.150ns 0.000V 105.100ns 0.000V 105.150ns 0.700V 107.100ns 0.700V 107.150ns 0.000V 109.100ns 0.000V 109.150ns 0.700V 111.100ns 0.700V 111.150ns 0.000V 113.100ns 0.000V 113.150ns 0.700V 115.100ns 0.700V 115.150ns 0.000V 117.100ns 0.000V 117.150ns 0.700V 119.100ns 0.700V 119.150ns 0.000V 121.100ns 0.000V 121.150ns 0.700V 123.100ns 0.700V 123.150ns 0.000V 125.100ns 0.000V 125.150ns 0.700V 127.100ns 0.700V 127.150ns 0.000V 129.100ns 0.000V 129.150ns 0.700V)
VA1 A1 GND PWL(0ns 0.000V 7.100ns 0.000V 7.150ns 0.700V 11.100ns 0.700V 11.150ns 0.000V 15.100ns 0.000V 15.150ns 0.700V 19.100ns 0.700V 19.150ns 0.000V 23.100ns 0.000V 23.150ns 0.700V 27.100ns 0.700V 27.150ns 0.000V 31.100ns 0.000V 31.150ns 0.700V 35.100ns 0.700V 35.150ns 0.000V 39.100ns 0.000V 39.150ns 0.700V 43.100ns 0.700V 43.150ns 0.000V 47.100ns 0.000V 47.150ns 0.700V 51.100ns 0.700V 51.150ns 0.000V 55.100ns 0.000V 55.150ns 0.700V 59.100ns 0.700V 59.150ns 0.000V 63.100ns 0.000V 63.150ns 0.700V 67.100ns 0.700V 67.150ns 0.000V 71.100ns 0.000V 71.150ns 0.700V 75.100ns 0.700V 75.150ns 0.000V 79.100ns 0.000V 79.150ns 0.700V 83.100ns 0.700V 83.150ns 0.000V 87.100ns 0.000V 87.150ns 0.700V 91.100ns 0.700V 91.150ns 0.000V 95.100ns 0.000V 95.150ns 0.700V 99.100ns 0.700V 99.150ns 0.000V 103.100ns 0.000V 103.150ns 0.700V 107.100ns 0.700V 107.150ns 0.000V 111.100ns 0.000V 111.150ns 0.700V 115.100ns 0.700V 115.150ns 0.000V 119.100ns 0.000V 119.150ns 0.700V 123.100ns 0.700V 123.150ns 0.000V 127.100ns 0.000V 127.150ns 0.700V)
VA2 A2 GND PWL(0ns 0.000V 11.100ns 0.000V 11.150ns 0.700V 19.100ns 0.700V 19.150ns 0.000V 27.100ns 0.000V 27.150ns 0.700V 35.100ns 0.700V 35.150ns 0.000V 43.100ns 0.000V 43.150ns 0.700V 51.100ns 0.700V 51.150ns 0.000V 59.100ns 0.000V 59.150ns 0.700V 67.100ns 0.700V 67.150ns 0.000V 75.100ns 0.000V 75.150ns 0.700V 83.100ns 0.700V 83.150ns 0.000V 91.100ns 0.000V 91.150ns 0.700V 99.100ns 0.700V 99.150ns 0.000V 107.100ns 0.000V 107.150ns 0.700V 115.100ns 0.700V 115.150ns 0.000V 123.100ns 0.000V 123.150ns 0.700V)
VA3 A3 GND PWL(0ns 0.000V 19.100ns 0.000V 19.150ns 0.700V 35.100ns 0.700V 35.150ns 0.000V 51.100ns 0.000V 51.150ns 0.700V 67.100ns 0.700V 67.150ns 0.000V 83.100ns 0.000V 83.150ns 0.700V 99.100ns 0.700V 99.150ns 0.000V 115.100ns 0.000V 115.150ns 0.700V)
VA4 A4 GND PWL(0ns 0.000V 35.100ns 0.000V 35.150ns 0.700V 67.100ns 0.700V 67.150ns 0.000V 99.100ns 0.000V 99.150ns 0.700V)
VA5 A5 GND PWL(0ns 0.000V 67.100ns 0.000V 67.150ns 0.700V)
VA6 A6 GND PWL(0ns 0.000V)

Vd0 D0 GND PWL(0ns 0.700V 4.100ns 0.700V 4.150ns 0.000V 35.100ns 0.000V 35.150ns 0.700V 36.100ns 0.700V 36.150ns 0.000V 67.100ns 0.000V 67.150ns 0.700V 68.100ns 0.700V 68.150ns 0.000V 99.100ns 0.000V 99.150ns 0.700V 100.100ns 0.700V 100.150ns 0.000V)
Vd1 D1 GND PWL(0ns 0.000V 5.100ns 0.000V 5.150ns 0.700V 6.100ns 0.700V 6.150ns 0.000V 37.100ns 0.000V 37.150ns 0.700V 38.100ns 0.700V 38.150ns 0.000V 69.100ns 0.000V 69.150ns 0.700V 70.100ns 0.700V 70.150ns 0.000V 101.100ns 0.000V 101.150ns 0.700V 102.100ns 0.700V 102.150ns 0.000V)
Vd2 D2 GND PWL(0ns 0.000V 7.100ns 0.000V 7.150ns 0.700V 8.100ns 0.700V 8.150ns 0.000V 39.100ns 0.000V 39.150ns 0.700V 40.100ns 0.700V 40.150ns 0.000V 71.100ns 0.000V 71.150ns 0.700V 72.100ns 0.700V 72.150ns 0.000V 103.100ns 0.000V 103.150ns 0.700V 104.100ns 0.700V 104.150ns 0.000V)
Vd3 D3 GND PWL(0ns 0.000V 9.100ns 0.000V 9.150ns 0.700V 10.100ns 0.700V 10.150ns 0.000V 41.100ns 0.000V 41.150ns 0.700V 42.100ns 0.700V 42.150ns 0.000V 73.100ns 0.000V 73.150ns 0.700V 74.100ns 0.700V 74.150ns 0.000V 105.100ns 0.000V 105.150ns 0.700V 106.100ns 0.700V 106.150ns 0.000V)
Vd4 D4 GND PWL(0ns 0.000V 11.100ns 0.000V 11.150ns 0.700V 12.100ns 0.700V 12.150ns 0.000V 43.100ns 0.000V 43.150ns 0.700V 44.100ns 0.700V 44.150ns 0.000V 75.100ns 0.000V 75.150ns 0.700V 76.100ns 0.700V 76.150ns 0.000V 107.100ns 0.000V 107.150ns 0.700V 108.100ns 0.700V 108.150ns 0.000V)
Vd5 D5 GND PWL(0ns 0.000V 13.100ns 0.000V 13.150ns 0.700V 14.100ns 0.700V 14.150ns 0.000V 45.100ns 0.000V 45.150ns 0.700V 46.100ns 0.700V 46.150ns 0.000V 77.100ns 0.000V 77.150ns 0.700V 78.100ns 0.700V 78.150ns 0.000V 109.100ns 0.000V 109.150ns 0.700V 110.100ns 0.700V 110.150ns 0.000V)
Vd6 D6 GND PWL(0ns 0.000V 15.100ns 0.000V 15.150ns 0.700V 16.100ns 0.700V 16.150ns 0.000V 47.100ns 0.000V 47.150ns 0.700V 48.100ns 0.700V 48.150ns 0.000V 79.100ns 0.000V 79.150ns 0.700V 80.100ns 0.700V 80.150ns 0.000V 111.100ns 0.000V 111.150ns 0.700V 112.100ns 0.700V 112.150ns 0.000V)
Vd7 D7 GND PWL(0ns 0.000V 17.100ns 0.000V 17.150ns 0.700V 18.100ns 0.700V 18.150ns 0.000V 49.100ns 0.000V 49.150ns 0.700V 50.100ns 0.700V 50.150ns 0.000V 81.100ns 0.000V 81.150ns 0.700V 82.100ns 0.700V 82.150ns 0.000V 113.100ns 0.000V 113.150ns 0.700V 114.100ns 0.700V 114.150ns 0.000V)
Vd8 D8 GND PWL(0ns 0.000V 19.100ns 0.000V 19.150ns 0.700V 20.100ns 0.700V 20.150ns 0.000V 51.100ns 0.000V 51.150ns 0.700V 52.100ns 0.700V 52.150ns 0.000V 83.100ns 0.000V 83.150ns 0.700V 84.100ns 0.700V 84.150ns 0.000V 115.100ns 0.000V 115.150ns 0.700V 116.100ns 0.700V 116.150ns 0.000V)
Vd9 D9 GND PWL(0ns 0.000V 21.100ns 0.000V 21.150ns 0.700V 22.100ns 0.700V 22.150ns 0.000V 53.100ns 0.000V 53.150ns 0.700V 54.100ns 0.700V 54.150ns 0.000V 85.100ns 0.000V 85.150ns 0.700V 86.100ns 0.700V 86.150ns 0.000V 117.100ns 0.000V 117.150ns 0.700V 118.100ns 0.700V 118.150ns 0.000V)
Vd10 D10 GND PWL(0ns 0.000V 23.100ns 0.000V 23.150ns 0.700V 24.100ns 0.700V 24.150ns 0.000V 55.100ns 0.000V 55.150ns 0.700V 56.100ns 0.700V 56.150ns 0.000V 87.100ns 0.000V 87.150ns 0.700V 88.100ns 0.700V 88.150ns 0.000V 119.100ns 0.000V 119.150ns 0.700V 120.100ns 0.700V 120.150ns 0.000V)
Vd11 D11 GND PWL(0ns 0.000V 25.100ns 0.000V 25.150ns 0.700V 26.100ns 0.700V 26.150ns 0.000V 57.100ns 0.000V 57.150ns 0.700V 58.100ns 0.700V 58.150ns 0.000V 89.100ns 0.000V 89.150ns 0.700V 90.100ns 0.700V 90.150ns 0.000V 121.100ns 0.000V 121.150ns 0.700V 122.100ns 0.700V 122.150ns 0.000V)
Vd12 D12 GND PWL(0ns 0.000V 27.100ns 0.000V 27.150ns 0.700V 28.100ns 0.700V 28.150ns 0.000V 59.100ns 0.000V 59.150ns 0.700V 60.100ns 0.700V 60.150ns 0.000V 91.100ns 0.000V 91.150ns 0.700V 92.100ns 0.700V 92.150ns 0.000V 123.100ns 0.000V 123.150ns 0.700V 124.100ns 0.700V 124.150ns 0.000V)
Vd13 D13 GND PWL(0ns 0.000V 29.100ns 0.000V 29.150ns 0.700V 30.100ns 0.700V 30.150ns 0.000V 61.100ns 0.000V 61.150ns 0.700V 62.100ns 0.700V 62.150ns 0.000V 93.100ns 0.000V 93.150ns 0.700V 94.100ns 0.700V 94.150ns 0.000V 125.100ns 0.000V 125.150ns 0.700V 126.100ns 0.700V 126.150ns 0.000V)
Vd14 D14 GND PWL(0ns 0.000V 31.100ns 0.000V 31.150ns 0.700V 32.100ns 0.700V 32.150ns 0.000V 63.100ns 0.000V 63.150ns 0.700V 64.100ns 0.700V 64.150ns 0.000V 95.100ns 0.000V 95.150ns 0.700V 96.100ns 0.700V 96.150ns 0.000V 127.100ns 0.000V 127.150ns 0.700V 128.100ns 0.700V 128.150ns 0.000V)
Vd15 D15 GND PWL(0ns 0.000V 33.100ns 0.000V 33.150ns 0.700V 34.100ns 0.700V 34.150ns 0.000V 65.100ns 0.000V 65.150ns 0.700V 66.100ns 0.700V 66.150ns 0.000V 97.100ns 0.000V 97.150ns 0.700V 98.100ns 0.700V 98.150ns 0.000V 129.100ns 0.000V 129.150ns 0.700V 130.100ns 0.700V 130.150ns 0.000V)
*****************************
**    Initial Conditions   **
*****************************
* Do not modify the initial conditions for BL and BLB, which are both 0V.
* We assume there is no initial voltage on the bitlines before precharge.
.ic v(XARRAY_TOP.xCOL0.BL0)	= 0v
.ic v(XARRAY_TOP.xCOL0.BLB0)	= 0v
.ic v(XARRAY_TOP.xCOL1.BL1)	= 0v
.ic v(XARRAY_TOP.xCOL1.BLB1)	= 0v
.ic v(XARRAY_TOP.xCOL2.BL2)	= 0v
.ic v(XARRAY_TOP.xCOL2.BLB2)	= 0v
.ic v(XARRAY_TOP.xCOL3.BL3)	= 0v
.ic v(XARRAY_TOP.xCOL3.BLB3)	= 0v
.ic v(XARRAY_TOP.xCOL4.BL4)	= 0v
.ic v(XARRAY_TOP.xCOL4.BLB4)	= 0v
.ic v(XARRAY_TOP.xCOL5.BL5)	= 0v
.ic v(XARRAY_TOP.xCOL5.BLB5)	= 0v
.ic v(XARRAY_TOP.xCOL6.BL6)	= 0v
.ic v(XARRAY_TOP.xCOL6.BLB6)	= 0v
.ic v(XARRAY_TOP.xCOL7.BL7)	= 0v
.ic v(XARRAY_TOP.xCOL7.BLB7)	= 0v
.ic v(XARRAY_TOP.xCOL8.BL8)	= 0v
.ic v(XARRAY_TOP.xCOL8.BLB8)	= 0v
.ic v(XARRAY_TOP.xCOL9.BL9)	= 0v
.ic v(XARRAY_TOP.xCOL9.BLB9)	= 0v
.ic v(XARRAY_TOP.xCOL10.BL10)	= 0v
.ic v(XARRAY_TOP.xCOL10.BLB10)	= 0v
.ic v(XARRAY_TOP.xCOL11.BL11)	= 0v
.ic v(XARRAY_TOP.xCOL11.BLB11)	= 0v
.ic v(XARRAY_TOP.xCOL12.BL12)	= 0v
.ic v(XARRAY_TOP.xCOL12.BLB12)	= 0v
.ic v(XARRAY_TOP.xCOL13.BL13)	= 0v
.ic v(XARRAY_TOP.xCOL13.BLB13)	= 0v
.ic v(XARRAY_TOP.xCOL14.BL14)	= 0v
.ic v(XARRAY_TOP.xCOL14.BLB14)	= 0v
.ic v(XARRAY_TOP.xCOL15.BL15)	= 0v
.ic v(XARRAY_TOP.xCOL15.BLB15)	= 0v
.ic v(XARRAY_TOP.xCOL16.BL16)	= 0v
.ic v(XARRAY_TOP.xCOL16.BLB16)	= 0v
.ic v(XARRAY_TOP.xCOL17.BL17)	= 0v
.ic v(XARRAY_TOP.xCOL17.BLB17)	= 0v
.ic v(XARRAY_TOP.xCOL18.BL18)	= 0v
.ic v(XARRAY_TOP.xCOL18.BLB18)	= 0v
.ic v(XARRAY_TOP.xCOL19.BL19)	= 0v
.ic v(XARRAY_TOP.xCOL19.BLB19)	= 0v
.ic v(XARRAY_TOP.xCOL20.BL20)	= 0v
.ic v(XARRAY_TOP.xCOL20.BLB20)	= 0v
.ic v(XARRAY_TOP.xCOL21.BL21)	= 0v
.ic v(XARRAY_TOP.xCOL21.BLB21)	= 0v
.ic v(XARRAY_TOP.xCOL22.BL22)	= 0v
.ic v(XARRAY_TOP.xCOL22.BLB22)	= 0v
.ic v(XARRAY_TOP.xCOL23.BL23)	= 0v
.ic v(XARRAY_TOP.xCOL23.BLB23)	= 0v
.ic v(XARRAY_TOP.xCOL24.BL24)	= 0v
.ic v(XARRAY_TOP.xCOL24.BLB24)	= 0v
.ic v(XARRAY_TOP.xCOL25.BL25)	= 0v
.ic v(XARRAY_TOP.xCOL25.BLB25)	= 0v
.ic v(XARRAY_TOP.xCOL26.BL26)	= 0v
.ic v(XARRAY_TOP.xCOL26.BLB26)	= 0v
.ic v(XARRAY_TOP.xCOL27.BL27)	= 0v
.ic v(XARRAY_TOP.xCOL27.BLB27)	= 0v
.ic v(XARRAY_TOP.xCOL28.BL28)	= 0v
.ic v(XARRAY_TOP.xCOL28.BLB28)	= 0v
.ic v(XARRAY_TOP.xCOL29.BL29)	= 0v
.ic v(XARRAY_TOP.xCOL29.BLB29)	= 0v
.ic v(XARRAY_TOP.xCOL30.BL30)	= 0v
.ic v(XARRAY_TOP.xCOL30.BLB30)	= 0v
.ic v(XARRAY_TOP.xCOL31.BL31)	= 0v
.ic v(XARRAY_TOP.xCOL31.BLB31)	= 0v

* You should set the initial conditions for q and qb in the SRAM.
* q should be 0V and qb should be 0.7V, which means the SRAM cell is storing "0".
.ic v(XARRAY_TOP.xCOL0.q0)	= 0v
.ic v(XARRAY_TOP.xCOL0.qb0)	= 0.7v
.ic v(XARRAY_TOP.xCOL1.q0)	= 0v
.ic v(XARRAY_TOP.xCOL1.qb0)	= 0.7v
.ic v(XARRAY_TOP.xCOL2.q0)	= 0v
.ic v(XARRAY_TOP.xCOL2.qb0)	= 0.7v
.ic v(XARRAY_TOP.xCOL3.q0)	= 0v
.ic v(XARRAY_TOP.xCOL3.qb0)	= 0.7v
.ic v(XARRAY_TOP.xCOL4.q0)	= 0v
.ic v(XARRAY_TOP.xCOL4.qb0)	= 0.7v
.ic v(XARRAY_TOP.xCOL5.q0)	= 0v
.ic v(XARRAY_TOP.xCOL5.qb0)	= 0.7v
.ic v(XARRAY_TOP.xCOL6.q0)	= 0v
.ic v(XARRAY_TOP.xCOL6.qb0)	= 0.7v
.ic v(XARRAY_TOP.xCOL7.q0)	= 0v
.ic v(XARRAY_TOP.xCOL7.qb0)	= 0.7v
.ic v(XARRAY_TOP.xCOL8.q0)	= 0v
.ic v(XARRAY_TOP.xCOL8.qb0)	= 0.7v
.ic v(XARRAY_TOP.xCOL9.q0)	= 0v
.ic v(XARRAY_TOP.xCOL9.qb0)	= 0.7v
.ic v(XARRAY_TOP.xCOL10.q0)	= 0v
.ic v(XARRAY_TOP.xCOL10.qb0)	= 0.7v
.ic v(XARRAY_TOP.xCOL11.q0)	= 0v
.ic v(XARRAY_TOP.xCOL11.qb0)	= 0.7v
.ic v(XARRAY_TOP.xCOL12.q0)	= 0v
.ic v(XARRAY_TOP.xCOL12.qb0)	= 0.7v
.ic v(XARRAY_TOP.xCOL13.q0)	= 0v
.ic v(XARRAY_TOP.xCOL13.qb0)	= 0.7v
.ic v(XARRAY_TOP.xCOL14.q0)	= 0v
.ic v(XARRAY_TOP.xCOL14.qb0)	= 0.7v
.ic v(XARRAY_TOP.xCOL15.q0)	= 0v
.ic v(XARRAY_TOP.xCOL15.qb0)	= 0.7v
.ic v(XARRAY_TOP.xCOL16.q0)	= 0v
.ic v(XARRAY_TOP.xCOL16.qb0)	= 0.7v
.ic v(XARRAY_TOP.xCOL17.q0)	= 0v
.ic v(XARRAY_TOP.xCOL17.qb0)	= 0.7v
.ic v(XARRAY_TOP.xCOL18.q0)	= 0v
.ic v(XARRAY_TOP.xCOL18.qb0)	= 0.7v
.ic v(XARRAY_TOP.xCOL19.q0)	= 0v
.ic v(XARRAY_TOP.xCOL19.qb0)	= 0.7v
.ic v(XARRAY_TOP.xCOL20.q0)	= 0v
.ic v(XARRAY_TOP.xCOL20.qb0)	= 0.7v
.ic v(XARRAY_TOP.xCOL21.q0)	= 0v
.ic v(XARRAY_TOP.xCOL21.qb0)	= 0.7v
.ic v(XARRAY_TOP.xCOL22.q0)	= 0v
.ic v(XARRAY_TOP.xCOL22.qb0)	= 0.7v
.ic v(XARRAY_TOP.xCOL23.q0)	= 0v
.ic v(XARRAY_TOP.xCOL23.qb0)	= 0.7v
.ic v(XARRAY_TOP.xCOL24.q0)	= 0v
.ic v(XARRAY_TOP.xCOL24.qb0)	= 0.7v
.ic v(XARRAY_TOP.xCOL25.q0)	= 0v
.ic v(XARRAY_TOP.xCOL25.qb0)	= 0.7v
.ic v(XARRAY_TOP.xCOL26.q0)	= 0v
.ic v(XARRAY_TOP.xCOL26.qb0)	= 0.7v
.ic v(XARRAY_TOP.xCOL27.q0)	= 0v
.ic v(XARRAY_TOP.xCOL27.qb0)	= 0.7v
.ic v(XARRAY_TOP.xCOL28.q0)	= 0v
.ic v(XARRAY_TOP.xCOL28.qb0)	= 0.7v
.ic v(XARRAY_TOP.xCOL29.q0)	= 0v
.ic v(XARRAY_TOP.xCOL29.qb0)	= 0.7v
.ic v(XARRAY_TOP.xCOL30.q0)	= 0v
.ic v(XARRAY_TOP.xCOL30.qb0)	= 0.7v
.ic v(XARRAY_TOP.xCOL31.q0)	= 0v
.ic v(XARRAY_TOP.xCOL31.qb0)	= 0.7v
.ic v(XARRAY_TOP.xCOL0.q1)	= 0v
.ic v(XARRAY_TOP.xCOL0.qb1)	= 0.7v
.ic v(XARRAY_TOP.xCOL1.q1)	= 0v
.ic v(XARRAY_TOP.xCOL1.qb1)	= 0.7v
.ic v(XARRAY_TOP.xCOL2.q1)	= 0v
.ic v(XARRAY_TOP.xCOL2.qb1)	= 0.7v
.ic v(XARRAY_TOP.xCOL3.q1)	= 0v
.ic v(XARRAY_TOP.xCOL3.qb1)	= 0.7v
.ic v(XARRAY_TOP.xCOL4.q1)	= 0v
.ic v(XARRAY_TOP.xCOL4.qb1)	= 0.7v
.ic v(XARRAY_TOP.xCOL5.q1)	= 0v
.ic v(XARRAY_TOP.xCOL5.qb1)	= 0.7v
.ic v(XARRAY_TOP.xCOL6.q1)	= 0v
.ic v(XARRAY_TOP.xCOL6.qb1)	= 0.7v
.ic v(XARRAY_TOP.xCOL7.q1)	= 0v
.ic v(XARRAY_TOP.xCOL7.qb1)	= 0.7v
.ic v(XARRAY_TOP.xCOL8.q1)	= 0v
.ic v(XARRAY_TOP.xCOL8.qb1)	= 0.7v
.ic v(XARRAY_TOP.xCOL9.q1)	= 0v
.ic v(XARRAY_TOP.xCOL9.qb1)	= 0.7v
.ic v(XARRAY_TOP.xCOL10.q1)	= 0v
.ic v(XARRAY_TOP.xCOL10.qb1)	= 0.7v
.ic v(XARRAY_TOP.xCOL11.q1)	= 0v
.ic v(XARRAY_TOP.xCOL11.qb1)	= 0.7v
.ic v(XARRAY_TOP.xCOL12.q1)	= 0v
.ic v(XARRAY_TOP.xCOL12.qb1)	= 0.7v
.ic v(XARRAY_TOP.xCOL13.q1)	= 0v
.ic v(XARRAY_TOP.xCOL13.qb1)	= 0.7v
.ic v(XARRAY_TOP.xCOL14.q1)	= 0v
.ic v(XARRAY_TOP.xCOL14.qb1)	= 0.7v
.ic v(XARRAY_TOP.xCOL15.q1)	= 0v
.ic v(XARRAY_TOP.xCOL15.qb1)	= 0.7v
.ic v(XARRAY_TOP.xCOL16.q1)	= 0v
.ic v(XARRAY_TOP.xCOL16.qb1)	= 0.7v
.ic v(XARRAY_TOP.xCOL17.q1)	= 0v
.ic v(XARRAY_TOP.xCOL17.qb1)	= 0.7v
.ic v(XARRAY_TOP.xCOL18.q1)	= 0v
.ic v(XARRAY_TOP.xCOL18.qb1)	= 0.7v
.ic v(XARRAY_TOP.xCOL19.q1)	= 0v
.ic v(XARRAY_TOP.xCOL19.qb1)	= 0.7v
.ic v(XARRAY_TOP.xCOL20.q1)	= 0v
.ic v(XARRAY_TOP.xCOL20.qb1)	= 0.7v
.ic v(XARRAY_TOP.xCOL21.q1)	= 0v
.ic v(XARRAY_TOP.xCOL21.qb1)	= 0.7v
.ic v(XARRAY_TOP.xCOL22.q1)	= 0v
.ic v(XARRAY_TOP.xCOL22.qb1)	= 0.7v
.ic v(XARRAY_TOP.xCOL23.q1)	= 0v
.ic v(XARRAY_TOP.xCOL23.qb1)	= 0.7v
.ic v(XARRAY_TOP.xCOL24.q1)	= 0v
.ic v(XARRAY_TOP.xCOL24.qb1)	= 0.7v
.ic v(XARRAY_TOP.xCOL25.q1)	= 0v
.ic v(XARRAY_TOP.xCOL25.qb1)	= 0.7v
.ic v(XARRAY_TOP.xCOL26.q1)	= 0v
.ic v(XARRAY_TOP.xCOL26.qb1)	= 0.7v
.ic v(XARRAY_TOP.xCOL27.q1)	= 0v
.ic v(XARRAY_TOP.xCOL27.qb1)	= 0.7v
.ic v(XARRAY_TOP.xCOL28.q1)	= 0v
.ic v(XARRAY_TOP.xCOL28.qb1)	= 0.7v
.ic v(XARRAY_TOP.xCOL29.q1)	= 0v
.ic v(XARRAY_TOP.xCOL29.qb1)	= 0.7v
.ic v(XARRAY_TOP.xCOL30.q1)	= 0v
.ic v(XARRAY_TOP.xCOL30.qb1)	= 0.7v
.ic v(XARRAY_TOP.xCOL31.q1)	= 0v
.ic v(XARRAY_TOP.xCOL31.qb1)	= 0.7v
.ic v(XARRAY_TOP.xCOL0.q2)	= 0v
.ic v(XARRAY_TOP.xCOL0.qb2)	= 0.7v
.ic v(XARRAY_TOP.xCOL1.q2)	= 0v
.ic v(XARRAY_TOP.xCOL1.qb2)	= 0.7v
.ic v(XARRAY_TOP.xCOL2.q2)	= 0v
.ic v(XARRAY_TOP.xCOL2.qb2)	= 0.7v
.ic v(XARRAY_TOP.xCOL3.q2)	= 0v
.ic v(XARRAY_TOP.xCOL3.qb2)	= 0.7v
.ic v(XARRAY_TOP.xCOL4.q2)	= 0v
.ic v(XARRAY_TOP.xCOL4.qb2)	= 0.7v
.ic v(XARRAY_TOP.xCOL5.q2)	= 0v
.ic v(XARRAY_TOP.xCOL5.qb2)	= 0.7v
.ic v(XARRAY_TOP.xCOL6.q2)	= 0v
.ic v(XARRAY_TOP.xCOL6.qb2)	= 0.7v
.ic v(XARRAY_TOP.xCOL7.q2)	= 0v
.ic v(XARRAY_TOP.xCOL7.qb2)	= 0.7v
.ic v(XARRAY_TOP.xCOL8.q2)	= 0v
.ic v(XARRAY_TOP.xCOL8.qb2)	= 0.7v
.ic v(XARRAY_TOP.xCOL9.q2)	= 0v
.ic v(XARRAY_TOP.xCOL9.qb2)	= 0.7v
.ic v(XARRAY_TOP.xCOL10.q2)	= 0v
.ic v(XARRAY_TOP.xCOL10.qb2)	= 0.7v
.ic v(XARRAY_TOP.xCOL11.q2)	= 0v
.ic v(XARRAY_TOP.xCOL11.qb2)	= 0.7v
.ic v(XARRAY_TOP.xCOL12.q2)	= 0v
.ic v(XARRAY_TOP.xCOL12.qb2)	= 0.7v
.ic v(XARRAY_TOP.xCOL13.q2)	= 0v
.ic v(XARRAY_TOP.xCOL13.qb2)	= 0.7v
.ic v(XARRAY_TOP.xCOL14.q2)	= 0v
.ic v(XARRAY_TOP.xCOL14.qb2)	= 0.7v
.ic v(XARRAY_TOP.xCOL15.q2)	= 0v
.ic v(XARRAY_TOP.xCOL15.qb2)	= 0.7v
.ic v(XARRAY_TOP.xCOL16.q2)	= 0v
.ic v(XARRAY_TOP.xCOL16.qb2)	= 0.7v
.ic v(XARRAY_TOP.xCOL17.q2)	= 0v
.ic v(XARRAY_TOP.xCOL17.qb2)	= 0.7v
.ic v(XARRAY_TOP.xCOL18.q2)	= 0v
.ic v(XARRAY_TOP.xCOL18.qb2)	= 0.7v
.ic v(XARRAY_TOP.xCOL19.q2)	= 0v
.ic v(XARRAY_TOP.xCOL19.qb2)	= 0.7v
.ic v(XARRAY_TOP.xCOL20.q2)	= 0v
.ic v(XARRAY_TOP.xCOL20.qb2)	= 0.7v
.ic v(XARRAY_TOP.xCOL21.q2)	= 0v
.ic v(XARRAY_TOP.xCOL21.qb2)	= 0.7v
.ic v(XARRAY_TOP.xCOL22.q2)	= 0v
.ic v(XARRAY_TOP.xCOL22.qb2)	= 0.7v
.ic v(XARRAY_TOP.xCOL23.q2)	= 0v
.ic v(XARRAY_TOP.xCOL23.qb2)	= 0.7v
.ic v(XARRAY_TOP.xCOL24.q2)	= 0v
.ic v(XARRAY_TOP.xCOL24.qb2)	= 0.7v
.ic v(XARRAY_TOP.xCOL25.q2)	= 0v
.ic v(XARRAY_TOP.xCOL25.qb2)	= 0.7v
.ic v(XARRAY_TOP.xCOL26.q2)	= 0v
.ic v(XARRAY_TOP.xCOL26.qb2)	= 0.7v
.ic v(XARRAY_TOP.xCOL27.q2)	= 0v
.ic v(XARRAY_TOP.xCOL27.qb2)	= 0.7v
.ic v(XARRAY_TOP.xCOL28.q2)	= 0v
.ic v(XARRAY_TOP.xCOL28.qb2)	= 0.7v
.ic v(XARRAY_TOP.xCOL29.q2)	= 0v
.ic v(XARRAY_TOP.xCOL29.qb2)	= 0.7v
.ic v(XARRAY_TOP.xCOL30.q2)	= 0v
.ic v(XARRAY_TOP.xCOL30.qb2)	= 0.7v
.ic v(XARRAY_TOP.xCOL31.q2)	= 0v
.ic v(XARRAY_TOP.xCOL31.qb2)	= 0.7v
.ic v(XARRAY_TOP.xCOL0.q3)	= 0v
.ic v(XARRAY_TOP.xCOL0.qb3)	= 0.7v
.ic v(XARRAY_TOP.xCOL1.q3)	= 0v
.ic v(XARRAY_TOP.xCOL1.qb3)	= 0.7v
.ic v(XARRAY_TOP.xCOL2.q3)	= 0v
.ic v(XARRAY_TOP.xCOL2.qb3)	= 0.7v
.ic v(XARRAY_TOP.xCOL3.q3)	= 0v
.ic v(XARRAY_TOP.xCOL3.qb3)	= 0.7v
.ic v(XARRAY_TOP.xCOL4.q3)	= 0v
.ic v(XARRAY_TOP.xCOL4.qb3)	= 0.7v
.ic v(XARRAY_TOP.xCOL5.q3)	= 0v
.ic v(XARRAY_TOP.xCOL5.qb3)	= 0.7v
.ic v(XARRAY_TOP.xCOL6.q3)	= 0v
.ic v(XARRAY_TOP.xCOL6.qb3)	= 0.7v
.ic v(XARRAY_TOP.xCOL7.q3)	= 0v
.ic v(XARRAY_TOP.xCOL7.qb3)	= 0.7v
.ic v(XARRAY_TOP.xCOL8.q3)	= 0v
.ic v(XARRAY_TOP.xCOL8.qb3)	= 0.7v
.ic v(XARRAY_TOP.xCOL9.q3)	= 0v
.ic v(XARRAY_TOP.xCOL9.qb3)	= 0.7v
.ic v(XARRAY_TOP.xCOL10.q3)	= 0v
.ic v(XARRAY_TOP.xCOL10.qb3)	= 0.7v
.ic v(XARRAY_TOP.xCOL11.q3)	= 0v
.ic v(XARRAY_TOP.xCOL11.qb3)	= 0.7v
.ic v(XARRAY_TOP.xCOL12.q3)	= 0v
.ic v(XARRAY_TOP.xCOL12.qb3)	= 0.7v
.ic v(XARRAY_TOP.xCOL13.q3)	= 0v
.ic v(XARRAY_TOP.xCOL13.qb3)	= 0.7v
.ic v(XARRAY_TOP.xCOL14.q3)	= 0v
.ic v(XARRAY_TOP.xCOL14.qb3)	= 0.7v
.ic v(XARRAY_TOP.xCOL15.q3)	= 0v
.ic v(XARRAY_TOP.xCOL15.qb3)	= 0.7v
.ic v(XARRAY_TOP.xCOL16.q3)	= 0v
.ic v(XARRAY_TOP.xCOL16.qb3)	= 0.7v
.ic v(XARRAY_TOP.xCOL17.q3)	= 0v
.ic v(XARRAY_TOP.xCOL17.qb3)	= 0.7v
.ic v(XARRAY_TOP.xCOL18.q3)	= 0v
.ic v(XARRAY_TOP.xCOL18.qb3)	= 0.7v
.ic v(XARRAY_TOP.xCOL19.q3)	= 0v
.ic v(XARRAY_TOP.xCOL19.qb3)	= 0.7v
.ic v(XARRAY_TOP.xCOL20.q3)	= 0v
.ic v(XARRAY_TOP.xCOL20.qb3)	= 0.7v
.ic v(XARRAY_TOP.xCOL21.q3)	= 0v
.ic v(XARRAY_TOP.xCOL21.qb3)	= 0.7v
.ic v(XARRAY_TOP.xCOL22.q3)	= 0v
.ic v(XARRAY_TOP.xCOL22.qb3)	= 0.7v
.ic v(XARRAY_TOP.xCOL23.q3)	= 0v
.ic v(XARRAY_TOP.xCOL23.qb3)	= 0.7v
.ic v(XARRAY_TOP.xCOL24.q3)	= 0v
.ic v(XARRAY_TOP.xCOL24.qb3)	= 0.7v
.ic v(XARRAY_TOP.xCOL25.q3)	= 0v
.ic v(XARRAY_TOP.xCOL25.qb3)	= 0.7v
.ic v(XARRAY_TOP.xCOL26.q3)	= 0v
.ic v(XARRAY_TOP.xCOL26.qb3)	= 0.7v
.ic v(XARRAY_TOP.xCOL27.q3)	= 0v
.ic v(XARRAY_TOP.xCOL27.qb3)	= 0.7v
.ic v(XARRAY_TOP.xCOL28.q3)	= 0v
.ic v(XARRAY_TOP.xCOL28.qb3)	= 0.7v
.ic v(XARRAY_TOP.xCOL29.q3)	= 0v
.ic v(XARRAY_TOP.xCOL29.qb3)	= 0.7v
.ic v(XARRAY_TOP.xCOL30.q3)	= 0v
.ic v(XARRAY_TOP.xCOL30.qb3)	= 0.7v
.ic v(XARRAY_TOP.xCOL31.q3)	= 0v
.ic v(XARRAY_TOP.xCOL31.qb3)	= 0.7v
.ic v(XARRAY_TOP.xCOL0.q4)	= 0v
.ic v(XARRAY_TOP.xCOL0.qb4)	= 0.7v
.ic v(XARRAY_TOP.xCOL1.q4)	= 0v
.ic v(XARRAY_TOP.xCOL1.qb4)	= 0.7v
.ic v(XARRAY_TOP.xCOL2.q4)	= 0v
.ic v(XARRAY_TOP.xCOL2.qb4)	= 0.7v
.ic v(XARRAY_TOP.xCOL3.q4)	= 0v
.ic v(XARRAY_TOP.xCOL3.qb4)	= 0.7v
.ic v(XARRAY_TOP.xCOL4.q4)	= 0v
.ic v(XARRAY_TOP.xCOL4.qb4)	= 0.7v
.ic v(XARRAY_TOP.xCOL5.q4)	= 0v
.ic v(XARRAY_TOP.xCOL5.qb4)	= 0.7v
.ic v(XARRAY_TOP.xCOL6.q4)	= 0v
.ic v(XARRAY_TOP.xCOL6.qb4)	= 0.7v
.ic v(XARRAY_TOP.xCOL7.q4)	= 0v
.ic v(XARRAY_TOP.xCOL7.qb4)	= 0.7v
.ic v(XARRAY_TOP.xCOL8.q4)	= 0v
.ic v(XARRAY_TOP.xCOL8.qb4)	= 0.7v
.ic v(XARRAY_TOP.xCOL9.q4)	= 0v
.ic v(XARRAY_TOP.xCOL9.qb4)	= 0.7v
.ic v(XARRAY_TOP.xCOL10.q4)	= 0v
.ic v(XARRAY_TOP.xCOL10.qb4)	= 0.7v
.ic v(XARRAY_TOP.xCOL11.q4)	= 0v
.ic v(XARRAY_TOP.xCOL11.qb4)	= 0.7v
.ic v(XARRAY_TOP.xCOL12.q4)	= 0v
.ic v(XARRAY_TOP.xCOL12.qb4)	= 0.7v
.ic v(XARRAY_TOP.xCOL13.q4)	= 0v
.ic v(XARRAY_TOP.xCOL13.qb4)	= 0.7v
.ic v(XARRAY_TOP.xCOL14.q4)	= 0v
.ic v(XARRAY_TOP.xCOL14.qb4)	= 0.7v
.ic v(XARRAY_TOP.xCOL15.q4)	= 0v
.ic v(XARRAY_TOP.xCOL15.qb4)	= 0.7v
.ic v(XARRAY_TOP.xCOL16.q4)	= 0v
.ic v(XARRAY_TOP.xCOL16.qb4)	= 0.7v
.ic v(XARRAY_TOP.xCOL17.q4)	= 0v
.ic v(XARRAY_TOP.xCOL17.qb4)	= 0.7v
.ic v(XARRAY_TOP.xCOL18.q4)	= 0v
.ic v(XARRAY_TOP.xCOL18.qb4)	= 0.7v
.ic v(XARRAY_TOP.xCOL19.q4)	= 0v
.ic v(XARRAY_TOP.xCOL19.qb4)	= 0.7v
.ic v(XARRAY_TOP.xCOL20.q4)	= 0v
.ic v(XARRAY_TOP.xCOL20.qb4)	= 0.7v
.ic v(XARRAY_TOP.xCOL21.q4)	= 0v
.ic v(XARRAY_TOP.xCOL21.qb4)	= 0.7v
.ic v(XARRAY_TOP.xCOL22.q4)	= 0v
.ic v(XARRAY_TOP.xCOL22.qb4)	= 0.7v
.ic v(XARRAY_TOP.xCOL23.q4)	= 0v
.ic v(XARRAY_TOP.xCOL23.qb4)	= 0.7v
.ic v(XARRAY_TOP.xCOL24.q4)	= 0v
.ic v(XARRAY_TOP.xCOL24.qb4)	= 0.7v
.ic v(XARRAY_TOP.xCOL25.q4)	= 0v
.ic v(XARRAY_TOP.xCOL25.qb4)	= 0.7v
.ic v(XARRAY_TOP.xCOL26.q4)	= 0v
.ic v(XARRAY_TOP.xCOL26.qb4)	= 0.7v
.ic v(XARRAY_TOP.xCOL27.q4)	= 0v
.ic v(XARRAY_TOP.xCOL27.qb4)	= 0.7v
.ic v(XARRAY_TOP.xCOL28.q4)	= 0v
.ic v(XARRAY_TOP.xCOL28.qb4)	= 0.7v
.ic v(XARRAY_TOP.xCOL29.q4)	= 0v
.ic v(XARRAY_TOP.xCOL29.qb4)	= 0.7v
.ic v(XARRAY_TOP.xCOL30.q4)	= 0v
.ic v(XARRAY_TOP.xCOL30.qb4)	= 0.7v
.ic v(XARRAY_TOP.xCOL31.q4)	= 0v
.ic v(XARRAY_TOP.xCOL31.qb4)	= 0.7v
.ic v(XARRAY_TOP.xCOL0.q5)	= 0v
.ic v(XARRAY_TOP.xCOL0.qb5)	= 0.7v
.ic v(XARRAY_TOP.xCOL1.q5)	= 0v
.ic v(XARRAY_TOP.xCOL1.qb5)	= 0.7v
.ic v(XARRAY_TOP.xCOL2.q5)	= 0v
.ic v(XARRAY_TOP.xCOL2.qb5)	= 0.7v
.ic v(XARRAY_TOP.xCOL3.q5)	= 0v
.ic v(XARRAY_TOP.xCOL3.qb5)	= 0.7v
.ic v(XARRAY_TOP.xCOL4.q5)	= 0v
.ic v(XARRAY_TOP.xCOL4.qb5)	= 0.7v
.ic v(XARRAY_TOP.xCOL5.q5)	= 0v
.ic v(XARRAY_TOP.xCOL5.qb5)	= 0.7v
.ic v(XARRAY_TOP.xCOL6.q5)	= 0v
.ic v(XARRAY_TOP.xCOL6.qb5)	= 0.7v
.ic v(XARRAY_TOP.xCOL7.q5)	= 0v
.ic v(XARRAY_TOP.xCOL7.qb5)	= 0.7v
.ic v(XARRAY_TOP.xCOL8.q5)	= 0v
.ic v(XARRAY_TOP.xCOL8.qb5)	= 0.7v
.ic v(XARRAY_TOP.xCOL9.q5)	= 0v
.ic v(XARRAY_TOP.xCOL9.qb5)	= 0.7v
.ic v(XARRAY_TOP.xCOL10.q5)	= 0v
.ic v(XARRAY_TOP.xCOL10.qb5)	= 0.7v
.ic v(XARRAY_TOP.xCOL11.q5)	= 0v
.ic v(XARRAY_TOP.xCOL11.qb5)	= 0.7v
.ic v(XARRAY_TOP.xCOL12.q5)	= 0v
.ic v(XARRAY_TOP.xCOL12.qb5)	= 0.7v
.ic v(XARRAY_TOP.xCOL13.q5)	= 0v
.ic v(XARRAY_TOP.xCOL13.qb5)	= 0.7v
.ic v(XARRAY_TOP.xCOL14.q5)	= 0v
.ic v(XARRAY_TOP.xCOL14.qb5)	= 0.7v
.ic v(XARRAY_TOP.xCOL15.q5)	= 0v
.ic v(XARRAY_TOP.xCOL15.qb5)	= 0.7v
.ic v(XARRAY_TOP.xCOL16.q5)	= 0v
.ic v(XARRAY_TOP.xCOL16.qb5)	= 0.7v
.ic v(XARRAY_TOP.xCOL17.q5)	= 0v
.ic v(XARRAY_TOP.xCOL17.qb5)	= 0.7v
.ic v(XARRAY_TOP.xCOL18.q5)	= 0v
.ic v(XARRAY_TOP.xCOL18.qb5)	= 0.7v
.ic v(XARRAY_TOP.xCOL19.q5)	= 0v
.ic v(XARRAY_TOP.xCOL19.qb5)	= 0.7v
.ic v(XARRAY_TOP.xCOL20.q5)	= 0v
.ic v(XARRAY_TOP.xCOL20.qb5)	= 0.7v
.ic v(XARRAY_TOP.xCOL21.q5)	= 0v
.ic v(XARRAY_TOP.xCOL21.qb5)	= 0.7v
.ic v(XARRAY_TOP.xCOL22.q5)	= 0v
.ic v(XARRAY_TOP.xCOL22.qb5)	= 0.7v
.ic v(XARRAY_TOP.xCOL23.q5)	= 0v
.ic v(XARRAY_TOP.xCOL23.qb5)	= 0.7v
.ic v(XARRAY_TOP.xCOL24.q5)	= 0v
.ic v(XARRAY_TOP.xCOL24.qb5)	= 0.7v
.ic v(XARRAY_TOP.xCOL25.q5)	= 0v
.ic v(XARRAY_TOP.xCOL25.qb5)	= 0.7v
.ic v(XARRAY_TOP.xCOL26.q5)	= 0v
.ic v(XARRAY_TOP.xCOL26.qb5)	= 0.7v
.ic v(XARRAY_TOP.xCOL27.q5)	= 0v
.ic v(XARRAY_TOP.xCOL27.qb5)	= 0.7v
.ic v(XARRAY_TOP.xCOL28.q5)	= 0v
.ic v(XARRAY_TOP.xCOL28.qb5)	= 0.7v
.ic v(XARRAY_TOP.xCOL29.q5)	= 0v
.ic v(XARRAY_TOP.xCOL29.qb5)	= 0.7v
.ic v(XARRAY_TOP.xCOL30.q5)	= 0v
.ic v(XARRAY_TOP.xCOL30.qb5)	= 0.7v
.ic v(XARRAY_TOP.xCOL31.q5)	= 0v
.ic v(XARRAY_TOP.xCOL31.qb5)	= 0.7v
.ic v(XARRAY_TOP.xCOL0.q6)	= 0v
.ic v(XARRAY_TOP.xCOL0.qb6)	= 0.7v
.ic v(XARRAY_TOP.xCOL1.q6)	= 0v
.ic v(XARRAY_TOP.xCOL1.qb6)	= 0.7v
.ic v(XARRAY_TOP.xCOL2.q6)	= 0v
.ic v(XARRAY_TOP.xCOL2.qb6)	= 0.7v
.ic v(XARRAY_TOP.xCOL3.q6)	= 0v
.ic v(XARRAY_TOP.xCOL3.qb6)	= 0.7v
.ic v(XARRAY_TOP.xCOL4.q6)	= 0v
.ic v(XARRAY_TOP.xCOL4.qb6)	= 0.7v
.ic v(XARRAY_TOP.xCOL5.q6)	= 0v
.ic v(XARRAY_TOP.xCOL5.qb6)	= 0.7v
.ic v(XARRAY_TOP.xCOL6.q6)	= 0v
.ic v(XARRAY_TOP.xCOL6.qb6)	= 0.7v
.ic v(XARRAY_TOP.xCOL7.q6)	= 0v
.ic v(XARRAY_TOP.xCOL7.qb6)	= 0.7v
.ic v(XARRAY_TOP.xCOL8.q6)	= 0v
.ic v(XARRAY_TOP.xCOL8.qb6)	= 0.7v
.ic v(XARRAY_TOP.xCOL9.q6)	= 0v
.ic v(XARRAY_TOP.xCOL9.qb6)	= 0.7v
.ic v(XARRAY_TOP.xCOL10.q6)	= 0v
.ic v(XARRAY_TOP.xCOL10.qb6)	= 0.7v
.ic v(XARRAY_TOP.xCOL11.q6)	= 0v
.ic v(XARRAY_TOP.xCOL11.qb6)	= 0.7v
.ic v(XARRAY_TOP.xCOL12.q6)	= 0v
.ic v(XARRAY_TOP.xCOL12.qb6)	= 0.7v
.ic v(XARRAY_TOP.xCOL13.q6)	= 0v
.ic v(XARRAY_TOP.xCOL13.qb6)	= 0.7v
.ic v(XARRAY_TOP.xCOL14.q6)	= 0v
.ic v(XARRAY_TOP.xCOL14.qb6)	= 0.7v
.ic v(XARRAY_TOP.xCOL15.q6)	= 0v
.ic v(XARRAY_TOP.xCOL15.qb6)	= 0.7v
.ic v(XARRAY_TOP.xCOL16.q6)	= 0v
.ic v(XARRAY_TOP.xCOL16.qb6)	= 0.7v
.ic v(XARRAY_TOP.xCOL17.q6)	= 0v
.ic v(XARRAY_TOP.xCOL17.qb6)	= 0.7v
.ic v(XARRAY_TOP.xCOL18.q6)	= 0v
.ic v(XARRAY_TOP.xCOL18.qb6)	= 0.7v
.ic v(XARRAY_TOP.xCOL19.q6)	= 0v
.ic v(XARRAY_TOP.xCOL19.qb6)	= 0.7v
.ic v(XARRAY_TOP.xCOL20.q6)	= 0v
.ic v(XARRAY_TOP.xCOL20.qb6)	= 0.7v
.ic v(XARRAY_TOP.xCOL21.q6)	= 0v
.ic v(XARRAY_TOP.xCOL21.qb6)	= 0.7v
.ic v(XARRAY_TOP.xCOL22.q6)	= 0v
.ic v(XARRAY_TOP.xCOL22.qb6)	= 0.7v
.ic v(XARRAY_TOP.xCOL23.q6)	= 0v
.ic v(XARRAY_TOP.xCOL23.qb6)	= 0.7v
.ic v(XARRAY_TOP.xCOL24.q6)	= 0v
.ic v(XARRAY_TOP.xCOL24.qb6)	= 0.7v
.ic v(XARRAY_TOP.xCOL25.q6)	= 0v
.ic v(XARRAY_TOP.xCOL25.qb6)	= 0.7v
.ic v(XARRAY_TOP.xCOL26.q6)	= 0v
.ic v(XARRAY_TOP.xCOL26.qb6)	= 0.7v
.ic v(XARRAY_TOP.xCOL27.q6)	= 0v
.ic v(XARRAY_TOP.xCOL27.qb6)	= 0.7v
.ic v(XARRAY_TOP.xCOL28.q6)	= 0v
.ic v(XARRAY_TOP.xCOL28.qb6)	= 0.7v
.ic v(XARRAY_TOP.xCOL29.q6)	= 0v
.ic v(XARRAY_TOP.xCOL29.qb6)	= 0.7v
.ic v(XARRAY_TOP.xCOL30.q6)	= 0v
.ic v(XARRAY_TOP.xCOL30.qb6)	= 0.7v
.ic v(XARRAY_TOP.xCOL31.q6)	= 0v
.ic v(XARRAY_TOP.xCOL31.qb6)	= 0.7v
.ic v(XARRAY_TOP.xCOL0.q7)	= 0v
.ic v(XARRAY_TOP.xCOL0.qb7)	= 0.7v
.ic v(XARRAY_TOP.xCOL1.q7)	= 0v
.ic v(XARRAY_TOP.xCOL1.qb7)	= 0.7v
.ic v(XARRAY_TOP.xCOL2.q7)	= 0v
.ic v(XARRAY_TOP.xCOL2.qb7)	= 0.7v
.ic v(XARRAY_TOP.xCOL3.q7)	= 0v
.ic v(XARRAY_TOP.xCOL3.qb7)	= 0.7v
.ic v(XARRAY_TOP.xCOL4.q7)	= 0v
.ic v(XARRAY_TOP.xCOL4.qb7)	= 0.7v
.ic v(XARRAY_TOP.xCOL5.q7)	= 0v
.ic v(XARRAY_TOP.xCOL5.qb7)	= 0.7v
.ic v(XARRAY_TOP.xCOL6.q7)	= 0v
.ic v(XARRAY_TOP.xCOL6.qb7)	= 0.7v
.ic v(XARRAY_TOP.xCOL7.q7)	= 0v
.ic v(XARRAY_TOP.xCOL7.qb7)	= 0.7v
.ic v(XARRAY_TOP.xCOL8.q7)	= 0v
.ic v(XARRAY_TOP.xCOL8.qb7)	= 0.7v
.ic v(XARRAY_TOP.xCOL9.q7)	= 0v
.ic v(XARRAY_TOP.xCOL9.qb7)	= 0.7v
.ic v(XARRAY_TOP.xCOL10.q7)	= 0v
.ic v(XARRAY_TOP.xCOL10.qb7)	= 0.7v
.ic v(XARRAY_TOP.xCOL11.q7)	= 0v
.ic v(XARRAY_TOP.xCOL11.qb7)	= 0.7v
.ic v(XARRAY_TOP.xCOL12.q7)	= 0v
.ic v(XARRAY_TOP.xCOL12.qb7)	= 0.7v
.ic v(XARRAY_TOP.xCOL13.q7)	= 0v
.ic v(XARRAY_TOP.xCOL13.qb7)	= 0.7v
.ic v(XARRAY_TOP.xCOL14.q7)	= 0v
.ic v(XARRAY_TOP.xCOL14.qb7)	= 0.7v
.ic v(XARRAY_TOP.xCOL15.q7)	= 0v
.ic v(XARRAY_TOP.xCOL15.qb7)	= 0.7v
.ic v(XARRAY_TOP.xCOL16.q7)	= 0v
.ic v(XARRAY_TOP.xCOL16.qb7)	= 0.7v
.ic v(XARRAY_TOP.xCOL17.q7)	= 0v
.ic v(XARRAY_TOP.xCOL17.qb7)	= 0.7v
.ic v(XARRAY_TOP.xCOL18.q7)	= 0v
.ic v(XARRAY_TOP.xCOL18.qb7)	= 0.7v
.ic v(XARRAY_TOP.xCOL19.q7)	= 0v
.ic v(XARRAY_TOP.xCOL19.qb7)	= 0.7v
.ic v(XARRAY_TOP.xCOL20.q7)	= 0v
.ic v(XARRAY_TOP.xCOL20.qb7)	= 0.7v
.ic v(XARRAY_TOP.xCOL21.q7)	= 0v
.ic v(XARRAY_TOP.xCOL21.qb7)	= 0.7v
.ic v(XARRAY_TOP.xCOL22.q7)	= 0v
.ic v(XARRAY_TOP.xCOL22.qb7)	= 0.7v
.ic v(XARRAY_TOP.xCOL23.q7)	= 0v
.ic v(XARRAY_TOP.xCOL23.qb7)	= 0.7v
.ic v(XARRAY_TOP.xCOL24.q7)	= 0v
.ic v(XARRAY_TOP.xCOL24.qb7)	= 0.7v
.ic v(XARRAY_TOP.xCOL25.q7)	= 0v
.ic v(XARRAY_TOP.xCOL25.qb7)	= 0.7v
.ic v(XARRAY_TOP.xCOL26.q7)	= 0v
.ic v(XARRAY_TOP.xCOL26.qb7)	= 0.7v
.ic v(XARRAY_TOP.xCOL27.q7)	= 0v
.ic v(XARRAY_TOP.xCOL27.qb7)	= 0.7v
.ic v(XARRAY_TOP.xCOL28.q7)	= 0v
.ic v(XARRAY_TOP.xCOL28.qb7)	= 0.7v
.ic v(XARRAY_TOP.xCOL29.q7)	= 0v
.ic v(XARRAY_TOP.xCOL29.qb7)	= 0.7v
.ic v(XARRAY_TOP.xCOL30.q7)	= 0v
.ic v(XARRAY_TOP.xCOL30.qb7)	= 0.7v
.ic v(XARRAY_TOP.xCOL31.q7)	= 0v
.ic v(XARRAY_TOP.xCOL31.qb7)	= 0.7v
.ic v(XARRAY_TOP.xCOL0.q8)	= 0v
.ic v(XARRAY_TOP.xCOL0.qb8)	= 0.7v
.ic v(XARRAY_TOP.xCOL1.q8)	= 0v
.ic v(XARRAY_TOP.xCOL1.qb8)	= 0.7v
.ic v(XARRAY_TOP.xCOL2.q8)	= 0v
.ic v(XARRAY_TOP.xCOL2.qb8)	= 0.7v
.ic v(XARRAY_TOP.xCOL3.q8)	= 0v
.ic v(XARRAY_TOP.xCOL3.qb8)	= 0.7v
.ic v(XARRAY_TOP.xCOL4.q8)	= 0v
.ic v(XARRAY_TOP.xCOL4.qb8)	= 0.7v
.ic v(XARRAY_TOP.xCOL5.q8)	= 0v
.ic v(XARRAY_TOP.xCOL5.qb8)	= 0.7v
.ic v(XARRAY_TOP.xCOL6.q8)	= 0v
.ic v(XARRAY_TOP.xCOL6.qb8)	= 0.7v
.ic v(XARRAY_TOP.xCOL7.q8)	= 0v
.ic v(XARRAY_TOP.xCOL7.qb8)	= 0.7v
.ic v(XARRAY_TOP.xCOL8.q8)	= 0v
.ic v(XARRAY_TOP.xCOL8.qb8)	= 0.7v
.ic v(XARRAY_TOP.xCOL9.q8)	= 0v
.ic v(XARRAY_TOP.xCOL9.qb8)	= 0.7v
.ic v(XARRAY_TOP.xCOL10.q8)	= 0v
.ic v(XARRAY_TOP.xCOL10.qb8)	= 0.7v
.ic v(XARRAY_TOP.xCOL11.q8)	= 0v
.ic v(XARRAY_TOP.xCOL11.qb8)	= 0.7v
.ic v(XARRAY_TOP.xCOL12.q8)	= 0v
.ic v(XARRAY_TOP.xCOL12.qb8)	= 0.7v
.ic v(XARRAY_TOP.xCOL13.q8)	= 0v
.ic v(XARRAY_TOP.xCOL13.qb8)	= 0.7v
.ic v(XARRAY_TOP.xCOL14.q8)	= 0v
.ic v(XARRAY_TOP.xCOL14.qb8)	= 0.7v
.ic v(XARRAY_TOP.xCOL15.q8)	= 0v
.ic v(XARRAY_TOP.xCOL15.qb8)	= 0.7v
.ic v(XARRAY_TOP.xCOL16.q8)	= 0v
.ic v(XARRAY_TOP.xCOL16.qb8)	= 0.7v
.ic v(XARRAY_TOP.xCOL17.q8)	= 0v
.ic v(XARRAY_TOP.xCOL17.qb8)	= 0.7v
.ic v(XARRAY_TOP.xCOL18.q8)	= 0v
.ic v(XARRAY_TOP.xCOL18.qb8)	= 0.7v
.ic v(XARRAY_TOP.xCOL19.q8)	= 0v
.ic v(XARRAY_TOP.xCOL19.qb8)	= 0.7v
.ic v(XARRAY_TOP.xCOL20.q8)	= 0v
.ic v(XARRAY_TOP.xCOL20.qb8)	= 0.7v
.ic v(XARRAY_TOP.xCOL21.q8)	= 0v
.ic v(XARRAY_TOP.xCOL21.qb8)	= 0.7v
.ic v(XARRAY_TOP.xCOL22.q8)	= 0v
.ic v(XARRAY_TOP.xCOL22.qb8)	= 0.7v
.ic v(XARRAY_TOP.xCOL23.q8)	= 0v
.ic v(XARRAY_TOP.xCOL23.qb8)	= 0.7v
.ic v(XARRAY_TOP.xCOL24.q8)	= 0v
.ic v(XARRAY_TOP.xCOL24.qb8)	= 0.7v
.ic v(XARRAY_TOP.xCOL25.q8)	= 0v
.ic v(XARRAY_TOP.xCOL25.qb8)	= 0.7v
.ic v(XARRAY_TOP.xCOL26.q8)	= 0v
.ic v(XARRAY_TOP.xCOL26.qb8)	= 0.7v
.ic v(XARRAY_TOP.xCOL27.q8)	= 0v
.ic v(XARRAY_TOP.xCOL27.qb8)	= 0.7v
.ic v(XARRAY_TOP.xCOL28.q8)	= 0v
.ic v(XARRAY_TOP.xCOL28.qb8)	= 0.7v
.ic v(XARRAY_TOP.xCOL29.q8)	= 0v
.ic v(XARRAY_TOP.xCOL29.qb8)	= 0.7v
.ic v(XARRAY_TOP.xCOL30.q8)	= 0v
.ic v(XARRAY_TOP.xCOL30.qb8)	= 0.7v
.ic v(XARRAY_TOP.xCOL31.q8)	= 0v
.ic v(XARRAY_TOP.xCOL31.qb8)	= 0.7v
.ic v(XARRAY_TOP.xCOL0.q9)	= 0v
.ic v(XARRAY_TOP.xCOL0.qb9)	= 0.7v
.ic v(XARRAY_TOP.xCOL1.q9)	= 0v
.ic v(XARRAY_TOP.xCOL1.qb9)	= 0.7v
.ic v(XARRAY_TOP.xCOL2.q9)	= 0v
.ic v(XARRAY_TOP.xCOL2.qb9)	= 0.7v
.ic v(XARRAY_TOP.xCOL3.q9)	= 0v
.ic v(XARRAY_TOP.xCOL3.qb9)	= 0.7v
.ic v(XARRAY_TOP.xCOL4.q9)	= 0v
.ic v(XARRAY_TOP.xCOL4.qb9)	= 0.7v
.ic v(XARRAY_TOP.xCOL5.q9)	= 0v
.ic v(XARRAY_TOP.xCOL5.qb9)	= 0.7v
.ic v(XARRAY_TOP.xCOL6.q9)	= 0v
.ic v(XARRAY_TOP.xCOL6.qb9)	= 0.7v
.ic v(XARRAY_TOP.xCOL7.q9)	= 0v
.ic v(XARRAY_TOP.xCOL7.qb9)	= 0.7v
.ic v(XARRAY_TOP.xCOL8.q9)	= 0v
.ic v(XARRAY_TOP.xCOL8.qb9)	= 0.7v
.ic v(XARRAY_TOP.xCOL9.q9)	= 0v
.ic v(XARRAY_TOP.xCOL9.qb9)	= 0.7v
.ic v(XARRAY_TOP.xCOL10.q9)	= 0v
.ic v(XARRAY_TOP.xCOL10.qb9)	= 0.7v
.ic v(XARRAY_TOP.xCOL11.q9)	= 0v
.ic v(XARRAY_TOP.xCOL11.qb9)	= 0.7v
.ic v(XARRAY_TOP.xCOL12.q9)	= 0v
.ic v(XARRAY_TOP.xCOL12.qb9)	= 0.7v
.ic v(XARRAY_TOP.xCOL13.q9)	= 0v
.ic v(XARRAY_TOP.xCOL13.qb9)	= 0.7v
.ic v(XARRAY_TOP.xCOL14.q9)	= 0v
.ic v(XARRAY_TOP.xCOL14.qb9)	= 0.7v
.ic v(XARRAY_TOP.xCOL15.q9)	= 0v
.ic v(XARRAY_TOP.xCOL15.qb9)	= 0.7v
.ic v(XARRAY_TOP.xCOL16.q9)	= 0v
.ic v(XARRAY_TOP.xCOL16.qb9)	= 0.7v
.ic v(XARRAY_TOP.xCOL17.q9)	= 0v
.ic v(XARRAY_TOP.xCOL17.qb9)	= 0.7v
.ic v(XARRAY_TOP.xCOL18.q9)	= 0v
.ic v(XARRAY_TOP.xCOL18.qb9)	= 0.7v
.ic v(XARRAY_TOP.xCOL19.q9)	= 0v
.ic v(XARRAY_TOP.xCOL19.qb9)	= 0.7v
.ic v(XARRAY_TOP.xCOL20.q9)	= 0v
.ic v(XARRAY_TOP.xCOL20.qb9)	= 0.7v
.ic v(XARRAY_TOP.xCOL21.q9)	= 0v
.ic v(XARRAY_TOP.xCOL21.qb9)	= 0.7v
.ic v(XARRAY_TOP.xCOL22.q9)	= 0v
.ic v(XARRAY_TOP.xCOL22.qb9)	= 0.7v
.ic v(XARRAY_TOP.xCOL23.q9)	= 0v
.ic v(XARRAY_TOP.xCOL23.qb9)	= 0.7v
.ic v(XARRAY_TOP.xCOL24.q9)	= 0v
.ic v(XARRAY_TOP.xCOL24.qb9)	= 0.7v
.ic v(XARRAY_TOP.xCOL25.q9)	= 0v
.ic v(XARRAY_TOP.xCOL25.qb9)	= 0.7v
.ic v(XARRAY_TOP.xCOL26.q9)	= 0v
.ic v(XARRAY_TOP.xCOL26.qb9)	= 0.7v
.ic v(XARRAY_TOP.xCOL27.q9)	= 0v
.ic v(XARRAY_TOP.xCOL27.qb9)	= 0.7v
.ic v(XARRAY_TOP.xCOL28.q9)	= 0v
.ic v(XARRAY_TOP.xCOL28.qb9)	= 0.7v
.ic v(XARRAY_TOP.xCOL29.q9)	= 0v
.ic v(XARRAY_TOP.xCOL29.qb9)	= 0.7v
.ic v(XARRAY_TOP.xCOL30.q9)	= 0v
.ic v(XARRAY_TOP.xCOL30.qb9)	= 0.7v
.ic v(XARRAY_TOP.xCOL31.q9)	= 0v
.ic v(XARRAY_TOP.xCOL31.qb9)	= 0.7v
.ic v(XARRAY_TOP.xCOL0.q10)	= 0v
.ic v(XARRAY_TOP.xCOL0.qb10)	= 0.7v
.ic v(XARRAY_TOP.xCOL1.q10)	= 0v
.ic v(XARRAY_TOP.xCOL1.qb10)	= 0.7v
.ic v(XARRAY_TOP.xCOL2.q10)	= 0v
.ic v(XARRAY_TOP.xCOL2.qb10)	= 0.7v
.ic v(XARRAY_TOP.xCOL3.q10)	= 0v
.ic v(XARRAY_TOP.xCOL3.qb10)	= 0.7v
.ic v(XARRAY_TOP.xCOL4.q10)	= 0v
.ic v(XARRAY_TOP.xCOL4.qb10)	= 0.7v
.ic v(XARRAY_TOP.xCOL5.q10)	= 0v
.ic v(XARRAY_TOP.xCOL5.qb10)	= 0.7v
.ic v(XARRAY_TOP.xCOL6.q10)	= 0v
.ic v(XARRAY_TOP.xCOL6.qb10)	= 0.7v
.ic v(XARRAY_TOP.xCOL7.q10)	= 0v
.ic v(XARRAY_TOP.xCOL7.qb10)	= 0.7v
.ic v(XARRAY_TOP.xCOL8.q10)	= 0v
.ic v(XARRAY_TOP.xCOL8.qb10)	= 0.7v
.ic v(XARRAY_TOP.xCOL9.q10)	= 0v
.ic v(XARRAY_TOP.xCOL9.qb10)	= 0.7v
.ic v(XARRAY_TOP.xCOL10.q10)	= 0v
.ic v(XARRAY_TOP.xCOL10.qb10)	= 0.7v
.ic v(XARRAY_TOP.xCOL11.q10)	= 0v
.ic v(XARRAY_TOP.xCOL11.qb10)	= 0.7v
.ic v(XARRAY_TOP.xCOL12.q10)	= 0v
.ic v(XARRAY_TOP.xCOL12.qb10)	= 0.7v
.ic v(XARRAY_TOP.xCOL13.q10)	= 0v
.ic v(XARRAY_TOP.xCOL13.qb10)	= 0.7v
.ic v(XARRAY_TOP.xCOL14.q10)	= 0v
.ic v(XARRAY_TOP.xCOL14.qb10)	= 0.7v
.ic v(XARRAY_TOP.xCOL15.q10)	= 0v
.ic v(XARRAY_TOP.xCOL15.qb10)	= 0.7v
.ic v(XARRAY_TOP.xCOL16.q10)	= 0v
.ic v(XARRAY_TOP.xCOL16.qb10)	= 0.7v
.ic v(XARRAY_TOP.xCOL17.q10)	= 0v
.ic v(XARRAY_TOP.xCOL17.qb10)	= 0.7v
.ic v(XARRAY_TOP.xCOL18.q10)	= 0v
.ic v(XARRAY_TOP.xCOL18.qb10)	= 0.7v
.ic v(XARRAY_TOP.xCOL19.q10)	= 0v
.ic v(XARRAY_TOP.xCOL19.qb10)	= 0.7v
.ic v(XARRAY_TOP.xCOL20.q10)	= 0v
.ic v(XARRAY_TOP.xCOL20.qb10)	= 0.7v
.ic v(XARRAY_TOP.xCOL21.q10)	= 0v
.ic v(XARRAY_TOP.xCOL21.qb10)	= 0.7v
.ic v(XARRAY_TOP.xCOL22.q10)	= 0v
.ic v(XARRAY_TOP.xCOL22.qb10)	= 0.7v
.ic v(XARRAY_TOP.xCOL23.q10)	= 0v
.ic v(XARRAY_TOP.xCOL23.qb10)	= 0.7v
.ic v(XARRAY_TOP.xCOL24.q10)	= 0v
.ic v(XARRAY_TOP.xCOL24.qb10)	= 0.7v
.ic v(XARRAY_TOP.xCOL25.q10)	= 0v
.ic v(XARRAY_TOP.xCOL25.qb10)	= 0.7v
.ic v(XARRAY_TOP.xCOL26.q10)	= 0v
.ic v(XARRAY_TOP.xCOL26.qb10)	= 0.7v
.ic v(XARRAY_TOP.xCOL27.q10)	= 0v
.ic v(XARRAY_TOP.xCOL27.qb10)	= 0.7v
.ic v(XARRAY_TOP.xCOL28.q10)	= 0v
.ic v(XARRAY_TOP.xCOL28.qb10)	= 0.7v
.ic v(XARRAY_TOP.xCOL29.q10)	= 0v
.ic v(XARRAY_TOP.xCOL29.qb10)	= 0.7v
.ic v(XARRAY_TOP.xCOL30.q10)	= 0v
.ic v(XARRAY_TOP.xCOL30.qb10)	= 0.7v
.ic v(XARRAY_TOP.xCOL31.q10)	= 0v
.ic v(XARRAY_TOP.xCOL31.qb10)	= 0.7v
.ic v(XARRAY_TOP.xCOL0.q11)	= 0v
.ic v(XARRAY_TOP.xCOL0.qb11)	= 0.7v
.ic v(XARRAY_TOP.xCOL1.q11)	= 0v
.ic v(XARRAY_TOP.xCOL1.qb11)	= 0.7v
.ic v(XARRAY_TOP.xCOL2.q11)	= 0v
.ic v(XARRAY_TOP.xCOL2.qb11)	= 0.7v
.ic v(XARRAY_TOP.xCOL3.q11)	= 0v
.ic v(XARRAY_TOP.xCOL3.qb11)	= 0.7v
.ic v(XARRAY_TOP.xCOL4.q11)	= 0v
.ic v(XARRAY_TOP.xCOL4.qb11)	= 0.7v
.ic v(XARRAY_TOP.xCOL5.q11)	= 0v
.ic v(XARRAY_TOP.xCOL5.qb11)	= 0.7v
.ic v(XARRAY_TOP.xCOL6.q11)	= 0v
.ic v(XARRAY_TOP.xCOL6.qb11)	= 0.7v
.ic v(XARRAY_TOP.xCOL7.q11)	= 0v
.ic v(XARRAY_TOP.xCOL7.qb11)	= 0.7v
.ic v(XARRAY_TOP.xCOL8.q11)	= 0v
.ic v(XARRAY_TOP.xCOL8.qb11)	= 0.7v
.ic v(XARRAY_TOP.xCOL9.q11)	= 0v
.ic v(XARRAY_TOP.xCOL9.qb11)	= 0.7v
.ic v(XARRAY_TOP.xCOL10.q11)	= 0v
.ic v(XARRAY_TOP.xCOL10.qb11)	= 0.7v
.ic v(XARRAY_TOP.xCOL11.q11)	= 0v
.ic v(XARRAY_TOP.xCOL11.qb11)	= 0.7v
.ic v(XARRAY_TOP.xCOL12.q11)	= 0v
.ic v(XARRAY_TOP.xCOL12.qb11)	= 0.7v
.ic v(XARRAY_TOP.xCOL13.q11)	= 0v
.ic v(XARRAY_TOP.xCOL13.qb11)	= 0.7v
.ic v(XARRAY_TOP.xCOL14.q11)	= 0v
.ic v(XARRAY_TOP.xCOL14.qb11)	= 0.7v
.ic v(XARRAY_TOP.xCOL15.q11)	= 0v
.ic v(XARRAY_TOP.xCOL15.qb11)	= 0.7v
.ic v(XARRAY_TOP.xCOL16.q11)	= 0v
.ic v(XARRAY_TOP.xCOL16.qb11)	= 0.7v
.ic v(XARRAY_TOP.xCOL17.q11)	= 0v
.ic v(XARRAY_TOP.xCOL17.qb11)	= 0.7v
.ic v(XARRAY_TOP.xCOL18.q11)	= 0v
.ic v(XARRAY_TOP.xCOL18.qb11)	= 0.7v
.ic v(XARRAY_TOP.xCOL19.q11)	= 0v
.ic v(XARRAY_TOP.xCOL19.qb11)	= 0.7v
.ic v(XARRAY_TOP.xCOL20.q11)	= 0v
.ic v(XARRAY_TOP.xCOL20.qb11)	= 0.7v
.ic v(XARRAY_TOP.xCOL21.q11)	= 0v
.ic v(XARRAY_TOP.xCOL21.qb11)	= 0.7v
.ic v(XARRAY_TOP.xCOL22.q11)	= 0v
.ic v(XARRAY_TOP.xCOL22.qb11)	= 0.7v
.ic v(XARRAY_TOP.xCOL23.q11)	= 0v
.ic v(XARRAY_TOP.xCOL23.qb11)	= 0.7v
.ic v(XARRAY_TOP.xCOL24.q11)	= 0v
.ic v(XARRAY_TOP.xCOL24.qb11)	= 0.7v
.ic v(XARRAY_TOP.xCOL25.q11)	= 0v
.ic v(XARRAY_TOP.xCOL25.qb11)	= 0.7v
.ic v(XARRAY_TOP.xCOL26.q11)	= 0v
.ic v(XARRAY_TOP.xCOL26.qb11)	= 0.7v
.ic v(XARRAY_TOP.xCOL27.q11)	= 0v
.ic v(XARRAY_TOP.xCOL27.qb11)	= 0.7v
.ic v(XARRAY_TOP.xCOL28.q11)	= 0v
.ic v(XARRAY_TOP.xCOL28.qb11)	= 0.7v
.ic v(XARRAY_TOP.xCOL29.q11)	= 0v
.ic v(XARRAY_TOP.xCOL29.qb11)	= 0.7v
.ic v(XARRAY_TOP.xCOL30.q11)	= 0v
.ic v(XARRAY_TOP.xCOL30.qb11)	= 0.7v
.ic v(XARRAY_TOP.xCOL31.q11)	= 0v
.ic v(XARRAY_TOP.xCOL31.qb11)	= 0.7v
.ic v(XARRAY_TOP.xCOL0.q12)	= 0v
.ic v(XARRAY_TOP.xCOL0.qb12)	= 0.7v
.ic v(XARRAY_TOP.xCOL1.q12)	= 0v
.ic v(XARRAY_TOP.xCOL1.qb12)	= 0.7v
.ic v(XARRAY_TOP.xCOL2.q12)	= 0v
.ic v(XARRAY_TOP.xCOL2.qb12)	= 0.7v
.ic v(XARRAY_TOP.xCOL3.q12)	= 0v
.ic v(XARRAY_TOP.xCOL3.qb12)	= 0.7v
.ic v(XARRAY_TOP.xCOL4.q12)	= 0v
.ic v(XARRAY_TOP.xCOL4.qb12)	= 0.7v
.ic v(XARRAY_TOP.xCOL5.q12)	= 0v
.ic v(XARRAY_TOP.xCOL5.qb12)	= 0.7v
.ic v(XARRAY_TOP.xCOL6.q12)	= 0v
.ic v(XARRAY_TOP.xCOL6.qb12)	= 0.7v
.ic v(XARRAY_TOP.xCOL7.q12)	= 0v
.ic v(XARRAY_TOP.xCOL7.qb12)	= 0.7v
.ic v(XARRAY_TOP.xCOL8.q12)	= 0v
.ic v(XARRAY_TOP.xCOL8.qb12)	= 0.7v
.ic v(XARRAY_TOP.xCOL9.q12)	= 0v
.ic v(XARRAY_TOP.xCOL9.qb12)	= 0.7v
.ic v(XARRAY_TOP.xCOL10.q12)	= 0v
.ic v(XARRAY_TOP.xCOL10.qb12)	= 0.7v
.ic v(XARRAY_TOP.xCOL11.q12)	= 0v
.ic v(XARRAY_TOP.xCOL11.qb12)	= 0.7v
.ic v(XARRAY_TOP.xCOL12.q12)	= 0v
.ic v(XARRAY_TOP.xCOL12.qb12)	= 0.7v
.ic v(XARRAY_TOP.xCOL13.q12)	= 0v
.ic v(XARRAY_TOP.xCOL13.qb12)	= 0.7v
.ic v(XARRAY_TOP.xCOL14.q12)	= 0v
.ic v(XARRAY_TOP.xCOL14.qb12)	= 0.7v
.ic v(XARRAY_TOP.xCOL15.q12)	= 0v
.ic v(XARRAY_TOP.xCOL15.qb12)	= 0.7v
.ic v(XARRAY_TOP.xCOL16.q12)	= 0v
.ic v(XARRAY_TOP.xCOL16.qb12)	= 0.7v
.ic v(XARRAY_TOP.xCOL17.q12)	= 0v
.ic v(XARRAY_TOP.xCOL17.qb12)	= 0.7v
.ic v(XARRAY_TOP.xCOL18.q12)	= 0v
.ic v(XARRAY_TOP.xCOL18.qb12)	= 0.7v
.ic v(XARRAY_TOP.xCOL19.q12)	= 0v
.ic v(XARRAY_TOP.xCOL19.qb12)	= 0.7v
.ic v(XARRAY_TOP.xCOL20.q12)	= 0v
.ic v(XARRAY_TOP.xCOL20.qb12)	= 0.7v
.ic v(XARRAY_TOP.xCOL21.q12)	= 0v
.ic v(XARRAY_TOP.xCOL21.qb12)	= 0.7v
.ic v(XARRAY_TOP.xCOL22.q12)	= 0v
.ic v(XARRAY_TOP.xCOL22.qb12)	= 0.7v
.ic v(XARRAY_TOP.xCOL23.q12)	= 0v
.ic v(XARRAY_TOP.xCOL23.qb12)	= 0.7v
.ic v(XARRAY_TOP.xCOL24.q12)	= 0v
.ic v(XARRAY_TOP.xCOL24.qb12)	= 0.7v
.ic v(XARRAY_TOP.xCOL25.q12)	= 0v
.ic v(XARRAY_TOP.xCOL25.qb12)	= 0.7v
.ic v(XARRAY_TOP.xCOL26.q12)	= 0v
.ic v(XARRAY_TOP.xCOL26.qb12)	= 0.7v
.ic v(XARRAY_TOP.xCOL27.q12)	= 0v
.ic v(XARRAY_TOP.xCOL27.qb12)	= 0.7v
.ic v(XARRAY_TOP.xCOL28.q12)	= 0v
.ic v(XARRAY_TOP.xCOL28.qb12)	= 0.7v
.ic v(XARRAY_TOP.xCOL29.q12)	= 0v
.ic v(XARRAY_TOP.xCOL29.qb12)	= 0.7v
.ic v(XARRAY_TOP.xCOL30.q12)	= 0v
.ic v(XARRAY_TOP.xCOL30.qb12)	= 0.7v
.ic v(XARRAY_TOP.xCOL31.q12)	= 0v
.ic v(XARRAY_TOP.xCOL31.qb12)	= 0.7v
.ic v(XARRAY_TOP.xCOL0.q13)	= 0v
.ic v(XARRAY_TOP.xCOL0.qb13)	= 0.7v
.ic v(XARRAY_TOP.xCOL1.q13)	= 0v
.ic v(XARRAY_TOP.xCOL1.qb13)	= 0.7v
.ic v(XARRAY_TOP.xCOL2.q13)	= 0v
.ic v(XARRAY_TOP.xCOL2.qb13)	= 0.7v
.ic v(XARRAY_TOP.xCOL3.q13)	= 0v
.ic v(XARRAY_TOP.xCOL3.qb13)	= 0.7v
.ic v(XARRAY_TOP.xCOL4.q13)	= 0v
.ic v(XARRAY_TOP.xCOL4.qb13)	= 0.7v
.ic v(XARRAY_TOP.xCOL5.q13)	= 0v
.ic v(XARRAY_TOP.xCOL5.qb13)	= 0.7v
.ic v(XARRAY_TOP.xCOL6.q13)	= 0v
.ic v(XARRAY_TOP.xCOL6.qb13)	= 0.7v
.ic v(XARRAY_TOP.xCOL7.q13)	= 0v
.ic v(XARRAY_TOP.xCOL7.qb13)	= 0.7v
.ic v(XARRAY_TOP.xCOL8.q13)	= 0v
.ic v(XARRAY_TOP.xCOL8.qb13)	= 0.7v
.ic v(XARRAY_TOP.xCOL9.q13)	= 0v
.ic v(XARRAY_TOP.xCOL9.qb13)	= 0.7v
.ic v(XARRAY_TOP.xCOL10.q13)	= 0v
.ic v(XARRAY_TOP.xCOL10.qb13)	= 0.7v
.ic v(XARRAY_TOP.xCOL11.q13)	= 0v
.ic v(XARRAY_TOP.xCOL11.qb13)	= 0.7v
.ic v(XARRAY_TOP.xCOL12.q13)	= 0v
.ic v(XARRAY_TOP.xCOL12.qb13)	= 0.7v
.ic v(XARRAY_TOP.xCOL13.q13)	= 0v
.ic v(XARRAY_TOP.xCOL13.qb13)	= 0.7v
.ic v(XARRAY_TOP.xCOL14.q13)	= 0v
.ic v(XARRAY_TOP.xCOL14.qb13)	= 0.7v
.ic v(XARRAY_TOP.xCOL15.q13)	= 0v
.ic v(XARRAY_TOP.xCOL15.qb13)	= 0.7v
.ic v(XARRAY_TOP.xCOL16.q13)	= 0v
.ic v(XARRAY_TOP.xCOL16.qb13)	= 0.7v
.ic v(XARRAY_TOP.xCOL17.q13)	= 0v
.ic v(XARRAY_TOP.xCOL17.qb13)	= 0.7v
.ic v(XARRAY_TOP.xCOL18.q13)	= 0v
.ic v(XARRAY_TOP.xCOL18.qb13)	= 0.7v
.ic v(XARRAY_TOP.xCOL19.q13)	= 0v
.ic v(XARRAY_TOP.xCOL19.qb13)	= 0.7v
.ic v(XARRAY_TOP.xCOL20.q13)	= 0v
.ic v(XARRAY_TOP.xCOL20.qb13)	= 0.7v
.ic v(XARRAY_TOP.xCOL21.q13)	= 0v
.ic v(XARRAY_TOP.xCOL21.qb13)	= 0.7v
.ic v(XARRAY_TOP.xCOL22.q13)	= 0v
.ic v(XARRAY_TOP.xCOL22.qb13)	= 0.7v
.ic v(XARRAY_TOP.xCOL23.q13)	= 0v
.ic v(XARRAY_TOP.xCOL23.qb13)	= 0.7v
.ic v(XARRAY_TOP.xCOL24.q13)	= 0v
.ic v(XARRAY_TOP.xCOL24.qb13)	= 0.7v
.ic v(XARRAY_TOP.xCOL25.q13)	= 0v
.ic v(XARRAY_TOP.xCOL25.qb13)	= 0.7v
.ic v(XARRAY_TOP.xCOL26.q13)	= 0v
.ic v(XARRAY_TOP.xCOL26.qb13)	= 0.7v
.ic v(XARRAY_TOP.xCOL27.q13)	= 0v
.ic v(XARRAY_TOP.xCOL27.qb13)	= 0.7v
.ic v(XARRAY_TOP.xCOL28.q13)	= 0v
.ic v(XARRAY_TOP.xCOL28.qb13)	= 0.7v
.ic v(XARRAY_TOP.xCOL29.q13)	= 0v
.ic v(XARRAY_TOP.xCOL29.qb13)	= 0.7v
.ic v(XARRAY_TOP.xCOL30.q13)	= 0v
.ic v(XARRAY_TOP.xCOL30.qb13)	= 0.7v
.ic v(XARRAY_TOP.xCOL31.q13)	= 0v
.ic v(XARRAY_TOP.xCOL31.qb13)	= 0.7v
.ic v(XARRAY_TOP.xCOL0.q14)	= 0v
.ic v(XARRAY_TOP.xCOL0.qb14)	= 0.7v
.ic v(XARRAY_TOP.xCOL1.q14)	= 0v
.ic v(XARRAY_TOP.xCOL1.qb14)	= 0.7v
.ic v(XARRAY_TOP.xCOL2.q14)	= 0v
.ic v(XARRAY_TOP.xCOL2.qb14)	= 0.7v
.ic v(XARRAY_TOP.xCOL3.q14)	= 0v
.ic v(XARRAY_TOP.xCOL3.qb14)	= 0.7v
.ic v(XARRAY_TOP.xCOL4.q14)	= 0v
.ic v(XARRAY_TOP.xCOL4.qb14)	= 0.7v
.ic v(XARRAY_TOP.xCOL5.q14)	= 0v
.ic v(XARRAY_TOP.xCOL5.qb14)	= 0.7v
.ic v(XARRAY_TOP.xCOL6.q14)	= 0v
.ic v(XARRAY_TOP.xCOL6.qb14)	= 0.7v
.ic v(XARRAY_TOP.xCOL7.q14)	= 0v
.ic v(XARRAY_TOP.xCOL7.qb14)	= 0.7v
.ic v(XARRAY_TOP.xCOL8.q14)	= 0v
.ic v(XARRAY_TOP.xCOL8.qb14)	= 0.7v
.ic v(XARRAY_TOP.xCOL9.q14)	= 0v
.ic v(XARRAY_TOP.xCOL9.qb14)	= 0.7v
.ic v(XARRAY_TOP.xCOL10.q14)	= 0v
.ic v(XARRAY_TOP.xCOL10.qb14)	= 0.7v
.ic v(XARRAY_TOP.xCOL11.q14)	= 0v
.ic v(XARRAY_TOP.xCOL11.qb14)	= 0.7v
.ic v(XARRAY_TOP.xCOL12.q14)	= 0v
.ic v(XARRAY_TOP.xCOL12.qb14)	= 0.7v
.ic v(XARRAY_TOP.xCOL13.q14)	= 0v
.ic v(XARRAY_TOP.xCOL13.qb14)	= 0.7v
.ic v(XARRAY_TOP.xCOL14.q14)	= 0v
.ic v(XARRAY_TOP.xCOL14.qb14)	= 0.7v
.ic v(XARRAY_TOP.xCOL15.q14)	= 0v
.ic v(XARRAY_TOP.xCOL15.qb14)	= 0.7v
.ic v(XARRAY_TOP.xCOL16.q14)	= 0v
.ic v(XARRAY_TOP.xCOL16.qb14)	= 0.7v
.ic v(XARRAY_TOP.xCOL17.q14)	= 0v
.ic v(XARRAY_TOP.xCOL17.qb14)	= 0.7v
.ic v(XARRAY_TOP.xCOL18.q14)	= 0v
.ic v(XARRAY_TOP.xCOL18.qb14)	= 0.7v
.ic v(XARRAY_TOP.xCOL19.q14)	= 0v
.ic v(XARRAY_TOP.xCOL19.qb14)	= 0.7v
.ic v(XARRAY_TOP.xCOL20.q14)	= 0v
.ic v(XARRAY_TOP.xCOL20.qb14)	= 0.7v
.ic v(XARRAY_TOP.xCOL21.q14)	= 0v
.ic v(XARRAY_TOP.xCOL21.qb14)	= 0.7v
.ic v(XARRAY_TOP.xCOL22.q14)	= 0v
.ic v(XARRAY_TOP.xCOL22.qb14)	= 0.7v
.ic v(XARRAY_TOP.xCOL23.q14)	= 0v
.ic v(XARRAY_TOP.xCOL23.qb14)	= 0.7v
.ic v(XARRAY_TOP.xCOL24.q14)	= 0v
.ic v(XARRAY_TOP.xCOL24.qb14)	= 0.7v
.ic v(XARRAY_TOP.xCOL25.q14)	= 0v
.ic v(XARRAY_TOP.xCOL25.qb14)	= 0.7v
.ic v(XARRAY_TOP.xCOL26.q14)	= 0v
.ic v(XARRAY_TOP.xCOL26.qb14)	= 0.7v
.ic v(XARRAY_TOP.xCOL27.q14)	= 0v
.ic v(XARRAY_TOP.xCOL27.qb14)	= 0.7v
.ic v(XARRAY_TOP.xCOL28.q14)	= 0v
.ic v(XARRAY_TOP.xCOL28.qb14)	= 0.7v
.ic v(XARRAY_TOP.xCOL29.q14)	= 0v
.ic v(XARRAY_TOP.xCOL29.qb14)	= 0.7v
.ic v(XARRAY_TOP.xCOL30.q14)	= 0v
.ic v(XARRAY_TOP.xCOL30.qb14)	= 0.7v
.ic v(XARRAY_TOP.xCOL31.q14)	= 0v
.ic v(XARRAY_TOP.xCOL31.qb14)	= 0.7v
.ic v(XARRAY_TOP.xCOL0.q15)	= 0v
.ic v(XARRAY_TOP.xCOL0.qb15)	= 0.7v
.ic v(XARRAY_TOP.xCOL1.q15)	= 0v
.ic v(XARRAY_TOP.xCOL1.qb15)	= 0.7v
.ic v(XARRAY_TOP.xCOL2.q15)	= 0v
.ic v(XARRAY_TOP.xCOL2.qb15)	= 0.7v
.ic v(XARRAY_TOP.xCOL3.q15)	= 0v
.ic v(XARRAY_TOP.xCOL3.qb15)	= 0.7v
.ic v(XARRAY_TOP.xCOL4.q15)	= 0v
.ic v(XARRAY_TOP.xCOL4.qb15)	= 0.7v
.ic v(XARRAY_TOP.xCOL5.q15)	= 0v
.ic v(XARRAY_TOP.xCOL5.qb15)	= 0.7v
.ic v(XARRAY_TOP.xCOL6.q15)	= 0v
.ic v(XARRAY_TOP.xCOL6.qb15)	= 0.7v
.ic v(XARRAY_TOP.xCOL7.q15)	= 0v
.ic v(XARRAY_TOP.xCOL7.qb15)	= 0.7v
.ic v(XARRAY_TOP.xCOL8.q15)	= 0v
.ic v(XARRAY_TOP.xCOL8.qb15)	= 0.7v
.ic v(XARRAY_TOP.xCOL9.q15)	= 0v
.ic v(XARRAY_TOP.xCOL9.qb15)	= 0.7v
.ic v(XARRAY_TOP.xCOL10.q15)	= 0v
.ic v(XARRAY_TOP.xCOL10.qb15)	= 0.7v
.ic v(XARRAY_TOP.xCOL11.q15)	= 0v
.ic v(XARRAY_TOP.xCOL11.qb15)	= 0.7v
.ic v(XARRAY_TOP.xCOL12.q15)	= 0v
.ic v(XARRAY_TOP.xCOL12.qb15)	= 0.7v
.ic v(XARRAY_TOP.xCOL13.q15)	= 0v
.ic v(XARRAY_TOP.xCOL13.qb15)	= 0.7v
.ic v(XARRAY_TOP.xCOL14.q15)	= 0v
.ic v(XARRAY_TOP.xCOL14.qb15)	= 0.7v
.ic v(XARRAY_TOP.xCOL15.q15)	= 0v
.ic v(XARRAY_TOP.xCOL15.qb15)	= 0.7v
.ic v(XARRAY_TOP.xCOL16.q15)	= 0v
.ic v(XARRAY_TOP.xCOL16.qb15)	= 0.7v
.ic v(XARRAY_TOP.xCOL17.q15)	= 0v
.ic v(XARRAY_TOP.xCOL17.qb15)	= 0.7v
.ic v(XARRAY_TOP.xCOL18.q15)	= 0v
.ic v(XARRAY_TOP.xCOL18.qb15)	= 0.7v
.ic v(XARRAY_TOP.xCOL19.q15)	= 0v
.ic v(XARRAY_TOP.xCOL19.qb15)	= 0.7v
.ic v(XARRAY_TOP.xCOL20.q15)	= 0v
.ic v(XARRAY_TOP.xCOL20.qb15)	= 0.7v
.ic v(XARRAY_TOP.xCOL21.q15)	= 0v
.ic v(XARRAY_TOP.xCOL21.qb15)	= 0.7v
.ic v(XARRAY_TOP.xCOL22.q15)	= 0v
.ic v(XARRAY_TOP.xCOL22.qb15)	= 0.7v
.ic v(XARRAY_TOP.xCOL23.q15)	= 0v
.ic v(XARRAY_TOP.xCOL23.qb15)	= 0.7v
.ic v(XARRAY_TOP.xCOL24.q15)	= 0v
.ic v(XARRAY_TOP.xCOL24.qb15)	= 0.7v
.ic v(XARRAY_TOP.xCOL25.q15)	= 0v
.ic v(XARRAY_TOP.xCOL25.qb15)	= 0.7v
.ic v(XARRAY_TOP.xCOL26.q15)	= 0v
.ic v(XARRAY_TOP.xCOL26.qb15)	= 0.7v
.ic v(XARRAY_TOP.xCOL27.q15)	= 0v
.ic v(XARRAY_TOP.xCOL27.qb15)	= 0.7v
.ic v(XARRAY_TOP.xCOL28.q15)	= 0v
.ic v(XARRAY_TOP.xCOL28.qb15)	= 0.7v
.ic v(XARRAY_TOP.xCOL29.q15)	= 0v
.ic v(XARRAY_TOP.xCOL29.qb15)	= 0.7v
.ic v(XARRAY_TOP.xCOL30.q15)	= 0v
.ic v(XARRAY_TOP.xCOL30.qb15)	= 0.7v
.ic v(XARRAY_TOP.xCOL31.q15)	= 0v
.ic v(XARRAY_TOP.xCOL31.qb15)	= 0.7v
.ic v(XARRAY_TOP.xCOL0.q16)	= 0v
.ic v(XARRAY_TOP.xCOL0.qb16)	= 0.7v
.ic v(XARRAY_TOP.xCOL1.q16)	= 0v
.ic v(XARRAY_TOP.xCOL1.qb16)	= 0.7v
.ic v(XARRAY_TOP.xCOL2.q16)	= 0v
.ic v(XARRAY_TOP.xCOL2.qb16)	= 0.7v
.ic v(XARRAY_TOP.xCOL3.q16)	= 0v
.ic v(XARRAY_TOP.xCOL3.qb16)	= 0.7v
.ic v(XARRAY_TOP.xCOL4.q16)	= 0v
.ic v(XARRAY_TOP.xCOL4.qb16)	= 0.7v
.ic v(XARRAY_TOP.xCOL5.q16)	= 0v
.ic v(XARRAY_TOP.xCOL5.qb16)	= 0.7v
.ic v(XARRAY_TOP.xCOL6.q16)	= 0v
.ic v(XARRAY_TOP.xCOL6.qb16)	= 0.7v
.ic v(XARRAY_TOP.xCOL7.q16)	= 0v
.ic v(XARRAY_TOP.xCOL7.qb16)	= 0.7v
.ic v(XARRAY_TOP.xCOL8.q16)	= 0v
.ic v(XARRAY_TOP.xCOL8.qb16)	= 0.7v
.ic v(XARRAY_TOP.xCOL9.q16)	= 0v
.ic v(XARRAY_TOP.xCOL9.qb16)	= 0.7v
.ic v(XARRAY_TOP.xCOL10.q16)	= 0v
.ic v(XARRAY_TOP.xCOL10.qb16)	= 0.7v
.ic v(XARRAY_TOP.xCOL11.q16)	= 0v
.ic v(XARRAY_TOP.xCOL11.qb16)	= 0.7v
.ic v(XARRAY_TOP.xCOL12.q16)	= 0v
.ic v(XARRAY_TOP.xCOL12.qb16)	= 0.7v
.ic v(XARRAY_TOP.xCOL13.q16)	= 0v
.ic v(XARRAY_TOP.xCOL13.qb16)	= 0.7v
.ic v(XARRAY_TOP.xCOL14.q16)	= 0v
.ic v(XARRAY_TOP.xCOL14.qb16)	= 0.7v
.ic v(XARRAY_TOP.xCOL15.q16)	= 0v
.ic v(XARRAY_TOP.xCOL15.qb16)	= 0.7v
.ic v(XARRAY_TOP.xCOL16.q16)	= 0v
.ic v(XARRAY_TOP.xCOL16.qb16)	= 0.7v
.ic v(XARRAY_TOP.xCOL17.q16)	= 0v
.ic v(XARRAY_TOP.xCOL17.qb16)	= 0.7v
.ic v(XARRAY_TOP.xCOL18.q16)	= 0v
.ic v(XARRAY_TOP.xCOL18.qb16)	= 0.7v
.ic v(XARRAY_TOP.xCOL19.q16)	= 0v
.ic v(XARRAY_TOP.xCOL19.qb16)	= 0.7v
.ic v(XARRAY_TOP.xCOL20.q16)	= 0v
.ic v(XARRAY_TOP.xCOL20.qb16)	= 0.7v
.ic v(XARRAY_TOP.xCOL21.q16)	= 0v
.ic v(XARRAY_TOP.xCOL21.qb16)	= 0.7v
.ic v(XARRAY_TOP.xCOL22.q16)	= 0v
.ic v(XARRAY_TOP.xCOL22.qb16)	= 0.7v
.ic v(XARRAY_TOP.xCOL23.q16)	= 0v
.ic v(XARRAY_TOP.xCOL23.qb16)	= 0.7v
.ic v(XARRAY_TOP.xCOL24.q16)	= 0v
.ic v(XARRAY_TOP.xCOL24.qb16)	= 0.7v
.ic v(XARRAY_TOP.xCOL25.q16)	= 0v
.ic v(XARRAY_TOP.xCOL25.qb16)	= 0.7v
.ic v(XARRAY_TOP.xCOL26.q16)	= 0v
.ic v(XARRAY_TOP.xCOL26.qb16)	= 0.7v
.ic v(XARRAY_TOP.xCOL27.q16)	= 0v
.ic v(XARRAY_TOP.xCOL27.qb16)	= 0.7v
.ic v(XARRAY_TOP.xCOL28.q16)	= 0v
.ic v(XARRAY_TOP.xCOL28.qb16)	= 0.7v
.ic v(XARRAY_TOP.xCOL29.q16)	= 0v
.ic v(XARRAY_TOP.xCOL29.qb16)	= 0.7v
.ic v(XARRAY_TOP.xCOL30.q16)	= 0v
.ic v(XARRAY_TOP.xCOL30.qb16)	= 0.7v
.ic v(XARRAY_TOP.xCOL31.q16)	= 0v
.ic v(XARRAY_TOP.xCOL31.qb16)	= 0.7v
.ic v(XARRAY_TOP.xCOL0.q17)	= 0v
.ic v(XARRAY_TOP.xCOL0.qb17)	= 0.7v
.ic v(XARRAY_TOP.xCOL1.q17)	= 0v
.ic v(XARRAY_TOP.xCOL1.qb17)	= 0.7v
.ic v(XARRAY_TOP.xCOL2.q17)	= 0v
.ic v(XARRAY_TOP.xCOL2.qb17)	= 0.7v
.ic v(XARRAY_TOP.xCOL3.q17)	= 0v
.ic v(XARRAY_TOP.xCOL3.qb17)	= 0.7v
.ic v(XARRAY_TOP.xCOL4.q17)	= 0v
.ic v(XARRAY_TOP.xCOL4.qb17)	= 0.7v
.ic v(XARRAY_TOP.xCOL5.q17)	= 0v
.ic v(XARRAY_TOP.xCOL5.qb17)	= 0.7v
.ic v(XARRAY_TOP.xCOL6.q17)	= 0v
.ic v(XARRAY_TOP.xCOL6.qb17)	= 0.7v
.ic v(XARRAY_TOP.xCOL7.q17)	= 0v
.ic v(XARRAY_TOP.xCOL7.qb17)	= 0.7v
.ic v(XARRAY_TOP.xCOL8.q17)	= 0v
.ic v(XARRAY_TOP.xCOL8.qb17)	= 0.7v
.ic v(XARRAY_TOP.xCOL9.q17)	= 0v
.ic v(XARRAY_TOP.xCOL9.qb17)	= 0.7v
.ic v(XARRAY_TOP.xCOL10.q17)	= 0v
.ic v(XARRAY_TOP.xCOL10.qb17)	= 0.7v
.ic v(XARRAY_TOP.xCOL11.q17)	= 0v
.ic v(XARRAY_TOP.xCOL11.qb17)	= 0.7v
.ic v(XARRAY_TOP.xCOL12.q17)	= 0v
.ic v(XARRAY_TOP.xCOL12.qb17)	= 0.7v
.ic v(XARRAY_TOP.xCOL13.q17)	= 0v
.ic v(XARRAY_TOP.xCOL13.qb17)	= 0.7v
.ic v(XARRAY_TOP.xCOL14.q17)	= 0v
.ic v(XARRAY_TOP.xCOL14.qb17)	= 0.7v
.ic v(XARRAY_TOP.xCOL15.q17)	= 0v
.ic v(XARRAY_TOP.xCOL15.qb17)	= 0.7v
.ic v(XARRAY_TOP.xCOL16.q17)	= 0v
.ic v(XARRAY_TOP.xCOL16.qb17)	= 0.7v
.ic v(XARRAY_TOP.xCOL17.q17)	= 0v
.ic v(XARRAY_TOP.xCOL17.qb17)	= 0.7v
.ic v(XARRAY_TOP.xCOL18.q17)	= 0v
.ic v(XARRAY_TOP.xCOL18.qb17)	= 0.7v
.ic v(XARRAY_TOP.xCOL19.q17)	= 0v
.ic v(XARRAY_TOP.xCOL19.qb17)	= 0.7v
.ic v(XARRAY_TOP.xCOL20.q17)	= 0v
.ic v(XARRAY_TOP.xCOL20.qb17)	= 0.7v
.ic v(XARRAY_TOP.xCOL21.q17)	= 0v
.ic v(XARRAY_TOP.xCOL21.qb17)	= 0.7v
.ic v(XARRAY_TOP.xCOL22.q17)	= 0v
.ic v(XARRAY_TOP.xCOL22.qb17)	= 0.7v
.ic v(XARRAY_TOP.xCOL23.q17)	= 0v
.ic v(XARRAY_TOP.xCOL23.qb17)	= 0.7v
.ic v(XARRAY_TOP.xCOL24.q17)	= 0v
.ic v(XARRAY_TOP.xCOL24.qb17)	= 0.7v
.ic v(XARRAY_TOP.xCOL25.q17)	= 0v
.ic v(XARRAY_TOP.xCOL25.qb17)	= 0.7v
.ic v(XARRAY_TOP.xCOL26.q17)	= 0v
.ic v(XARRAY_TOP.xCOL26.qb17)	= 0.7v
.ic v(XARRAY_TOP.xCOL27.q17)	= 0v
.ic v(XARRAY_TOP.xCOL27.qb17)	= 0.7v
.ic v(XARRAY_TOP.xCOL28.q17)	= 0v
.ic v(XARRAY_TOP.xCOL28.qb17)	= 0.7v
.ic v(XARRAY_TOP.xCOL29.q17)	= 0v
.ic v(XARRAY_TOP.xCOL29.qb17)	= 0.7v
.ic v(XARRAY_TOP.xCOL30.q17)	= 0v
.ic v(XARRAY_TOP.xCOL30.qb17)	= 0.7v
.ic v(XARRAY_TOP.xCOL31.q17)	= 0v
.ic v(XARRAY_TOP.xCOL31.qb17)	= 0.7v
.ic v(XARRAY_TOP.xCOL0.q18)	= 0v
.ic v(XARRAY_TOP.xCOL0.qb18)	= 0.7v
.ic v(XARRAY_TOP.xCOL1.q18)	= 0v
.ic v(XARRAY_TOP.xCOL1.qb18)	= 0.7v
.ic v(XARRAY_TOP.xCOL2.q18)	= 0v
.ic v(XARRAY_TOP.xCOL2.qb18)	= 0.7v
.ic v(XARRAY_TOP.xCOL3.q18)	= 0v
.ic v(XARRAY_TOP.xCOL3.qb18)	= 0.7v
.ic v(XARRAY_TOP.xCOL4.q18)	= 0v
.ic v(XARRAY_TOP.xCOL4.qb18)	= 0.7v
.ic v(XARRAY_TOP.xCOL5.q18)	= 0v
.ic v(XARRAY_TOP.xCOL5.qb18)	= 0.7v
.ic v(XARRAY_TOP.xCOL6.q18)	= 0v
.ic v(XARRAY_TOP.xCOL6.qb18)	= 0.7v
.ic v(XARRAY_TOP.xCOL7.q18)	= 0v
.ic v(XARRAY_TOP.xCOL7.qb18)	= 0.7v
.ic v(XARRAY_TOP.xCOL8.q18)	= 0v
.ic v(XARRAY_TOP.xCOL8.qb18)	= 0.7v
.ic v(XARRAY_TOP.xCOL9.q18)	= 0v
.ic v(XARRAY_TOP.xCOL9.qb18)	= 0.7v
.ic v(XARRAY_TOP.xCOL10.q18)	= 0v
.ic v(XARRAY_TOP.xCOL10.qb18)	= 0.7v
.ic v(XARRAY_TOP.xCOL11.q18)	= 0v
.ic v(XARRAY_TOP.xCOL11.qb18)	= 0.7v
.ic v(XARRAY_TOP.xCOL12.q18)	= 0v
.ic v(XARRAY_TOP.xCOL12.qb18)	= 0.7v
.ic v(XARRAY_TOP.xCOL13.q18)	= 0v
.ic v(XARRAY_TOP.xCOL13.qb18)	= 0.7v
.ic v(XARRAY_TOP.xCOL14.q18)	= 0v
.ic v(XARRAY_TOP.xCOL14.qb18)	= 0.7v
.ic v(XARRAY_TOP.xCOL15.q18)	= 0v
.ic v(XARRAY_TOP.xCOL15.qb18)	= 0.7v
.ic v(XARRAY_TOP.xCOL16.q18)	= 0v
.ic v(XARRAY_TOP.xCOL16.qb18)	= 0.7v
.ic v(XARRAY_TOP.xCOL17.q18)	= 0v
.ic v(XARRAY_TOP.xCOL17.qb18)	= 0.7v
.ic v(XARRAY_TOP.xCOL18.q18)	= 0v
.ic v(XARRAY_TOP.xCOL18.qb18)	= 0.7v
.ic v(XARRAY_TOP.xCOL19.q18)	= 0v
.ic v(XARRAY_TOP.xCOL19.qb18)	= 0.7v
.ic v(XARRAY_TOP.xCOL20.q18)	= 0v
.ic v(XARRAY_TOP.xCOL20.qb18)	= 0.7v
.ic v(XARRAY_TOP.xCOL21.q18)	= 0v
.ic v(XARRAY_TOP.xCOL21.qb18)	= 0.7v
.ic v(XARRAY_TOP.xCOL22.q18)	= 0v
.ic v(XARRAY_TOP.xCOL22.qb18)	= 0.7v
.ic v(XARRAY_TOP.xCOL23.q18)	= 0v
.ic v(XARRAY_TOP.xCOL23.qb18)	= 0.7v
.ic v(XARRAY_TOP.xCOL24.q18)	= 0v
.ic v(XARRAY_TOP.xCOL24.qb18)	= 0.7v
.ic v(XARRAY_TOP.xCOL25.q18)	= 0v
.ic v(XARRAY_TOP.xCOL25.qb18)	= 0.7v
.ic v(XARRAY_TOP.xCOL26.q18)	= 0v
.ic v(XARRAY_TOP.xCOL26.qb18)	= 0.7v
.ic v(XARRAY_TOP.xCOL27.q18)	= 0v
.ic v(XARRAY_TOP.xCOL27.qb18)	= 0.7v
.ic v(XARRAY_TOP.xCOL28.q18)	= 0v
.ic v(XARRAY_TOP.xCOL28.qb18)	= 0.7v
.ic v(XARRAY_TOP.xCOL29.q18)	= 0v
.ic v(XARRAY_TOP.xCOL29.qb18)	= 0.7v
.ic v(XARRAY_TOP.xCOL30.q18)	= 0v
.ic v(XARRAY_TOP.xCOL30.qb18)	= 0.7v
.ic v(XARRAY_TOP.xCOL31.q18)	= 0v
.ic v(XARRAY_TOP.xCOL31.qb18)	= 0.7v
.ic v(XARRAY_TOP.xCOL0.q19)	= 0v
.ic v(XARRAY_TOP.xCOL0.qb19)	= 0.7v
.ic v(XARRAY_TOP.xCOL1.q19)	= 0v
.ic v(XARRAY_TOP.xCOL1.qb19)	= 0.7v
.ic v(XARRAY_TOP.xCOL2.q19)	= 0v
.ic v(XARRAY_TOP.xCOL2.qb19)	= 0.7v
.ic v(XARRAY_TOP.xCOL3.q19)	= 0v
.ic v(XARRAY_TOP.xCOL3.qb19)	= 0.7v
.ic v(XARRAY_TOP.xCOL4.q19)	= 0v
.ic v(XARRAY_TOP.xCOL4.qb19)	= 0.7v
.ic v(XARRAY_TOP.xCOL5.q19)	= 0v
.ic v(XARRAY_TOP.xCOL5.qb19)	= 0.7v
.ic v(XARRAY_TOP.xCOL6.q19)	= 0v
.ic v(XARRAY_TOP.xCOL6.qb19)	= 0.7v
.ic v(XARRAY_TOP.xCOL7.q19)	= 0v
.ic v(XARRAY_TOP.xCOL7.qb19)	= 0.7v
.ic v(XARRAY_TOP.xCOL8.q19)	= 0v
.ic v(XARRAY_TOP.xCOL8.qb19)	= 0.7v
.ic v(XARRAY_TOP.xCOL9.q19)	= 0v
.ic v(XARRAY_TOP.xCOL9.qb19)	= 0.7v
.ic v(XARRAY_TOP.xCOL10.q19)	= 0v
.ic v(XARRAY_TOP.xCOL10.qb19)	= 0.7v
.ic v(XARRAY_TOP.xCOL11.q19)	= 0v
.ic v(XARRAY_TOP.xCOL11.qb19)	= 0.7v
.ic v(XARRAY_TOP.xCOL12.q19)	= 0v
.ic v(XARRAY_TOP.xCOL12.qb19)	= 0.7v
.ic v(XARRAY_TOP.xCOL13.q19)	= 0v
.ic v(XARRAY_TOP.xCOL13.qb19)	= 0.7v
.ic v(XARRAY_TOP.xCOL14.q19)	= 0v
.ic v(XARRAY_TOP.xCOL14.qb19)	= 0.7v
.ic v(XARRAY_TOP.xCOL15.q19)	= 0v
.ic v(XARRAY_TOP.xCOL15.qb19)	= 0.7v
.ic v(XARRAY_TOP.xCOL16.q19)	= 0v
.ic v(XARRAY_TOP.xCOL16.qb19)	= 0.7v
.ic v(XARRAY_TOP.xCOL17.q19)	= 0v
.ic v(XARRAY_TOP.xCOL17.qb19)	= 0.7v
.ic v(XARRAY_TOP.xCOL18.q19)	= 0v
.ic v(XARRAY_TOP.xCOL18.qb19)	= 0.7v
.ic v(XARRAY_TOP.xCOL19.q19)	= 0v
.ic v(XARRAY_TOP.xCOL19.qb19)	= 0.7v
.ic v(XARRAY_TOP.xCOL20.q19)	= 0v
.ic v(XARRAY_TOP.xCOL20.qb19)	= 0.7v
.ic v(XARRAY_TOP.xCOL21.q19)	= 0v
.ic v(XARRAY_TOP.xCOL21.qb19)	= 0.7v
.ic v(XARRAY_TOP.xCOL22.q19)	= 0v
.ic v(XARRAY_TOP.xCOL22.qb19)	= 0.7v
.ic v(XARRAY_TOP.xCOL23.q19)	= 0v
.ic v(XARRAY_TOP.xCOL23.qb19)	= 0.7v
.ic v(XARRAY_TOP.xCOL24.q19)	= 0v
.ic v(XARRAY_TOP.xCOL24.qb19)	= 0.7v
.ic v(XARRAY_TOP.xCOL25.q19)	= 0v
.ic v(XARRAY_TOP.xCOL25.qb19)	= 0.7v
.ic v(XARRAY_TOP.xCOL26.q19)	= 0v
.ic v(XARRAY_TOP.xCOL26.qb19)	= 0.7v
.ic v(XARRAY_TOP.xCOL27.q19)	= 0v
.ic v(XARRAY_TOP.xCOL27.qb19)	= 0.7v
.ic v(XARRAY_TOP.xCOL28.q19)	= 0v
.ic v(XARRAY_TOP.xCOL28.qb19)	= 0.7v
.ic v(XARRAY_TOP.xCOL29.q19)	= 0v
.ic v(XARRAY_TOP.xCOL29.qb19)	= 0.7v
.ic v(XARRAY_TOP.xCOL30.q19)	= 0v
.ic v(XARRAY_TOP.xCOL30.qb19)	= 0.7v
.ic v(XARRAY_TOP.xCOL31.q19)	= 0v
.ic v(XARRAY_TOP.xCOL31.qb19)	= 0.7v
.ic v(XARRAY_TOP.xCOL0.q20)	= 0v
.ic v(XARRAY_TOP.xCOL0.qb20)	= 0.7v
.ic v(XARRAY_TOP.xCOL1.q20)	= 0v
.ic v(XARRAY_TOP.xCOL1.qb20)	= 0.7v
.ic v(XARRAY_TOP.xCOL2.q20)	= 0v
.ic v(XARRAY_TOP.xCOL2.qb20)	= 0.7v
.ic v(XARRAY_TOP.xCOL3.q20)	= 0v
.ic v(XARRAY_TOP.xCOL3.qb20)	= 0.7v
.ic v(XARRAY_TOP.xCOL4.q20)	= 0v
.ic v(XARRAY_TOP.xCOL4.qb20)	= 0.7v
.ic v(XARRAY_TOP.xCOL5.q20)	= 0v
.ic v(XARRAY_TOP.xCOL5.qb20)	= 0.7v
.ic v(XARRAY_TOP.xCOL6.q20)	= 0v
.ic v(XARRAY_TOP.xCOL6.qb20)	= 0.7v
.ic v(XARRAY_TOP.xCOL7.q20)	= 0v
.ic v(XARRAY_TOP.xCOL7.qb20)	= 0.7v
.ic v(XARRAY_TOP.xCOL8.q20)	= 0v
.ic v(XARRAY_TOP.xCOL8.qb20)	= 0.7v
.ic v(XARRAY_TOP.xCOL9.q20)	= 0v
.ic v(XARRAY_TOP.xCOL9.qb20)	= 0.7v
.ic v(XARRAY_TOP.xCOL10.q20)	= 0v
.ic v(XARRAY_TOP.xCOL10.qb20)	= 0.7v
.ic v(XARRAY_TOP.xCOL11.q20)	= 0v
.ic v(XARRAY_TOP.xCOL11.qb20)	= 0.7v
.ic v(XARRAY_TOP.xCOL12.q20)	= 0v
.ic v(XARRAY_TOP.xCOL12.qb20)	= 0.7v
.ic v(XARRAY_TOP.xCOL13.q20)	= 0v
.ic v(XARRAY_TOP.xCOL13.qb20)	= 0.7v
.ic v(XARRAY_TOP.xCOL14.q20)	= 0v
.ic v(XARRAY_TOP.xCOL14.qb20)	= 0.7v
.ic v(XARRAY_TOP.xCOL15.q20)	= 0v
.ic v(XARRAY_TOP.xCOL15.qb20)	= 0.7v
.ic v(XARRAY_TOP.xCOL16.q20)	= 0v
.ic v(XARRAY_TOP.xCOL16.qb20)	= 0.7v
.ic v(XARRAY_TOP.xCOL17.q20)	= 0v
.ic v(XARRAY_TOP.xCOL17.qb20)	= 0.7v
.ic v(XARRAY_TOP.xCOL18.q20)	= 0v
.ic v(XARRAY_TOP.xCOL18.qb20)	= 0.7v
.ic v(XARRAY_TOP.xCOL19.q20)	= 0v
.ic v(XARRAY_TOP.xCOL19.qb20)	= 0.7v
.ic v(XARRAY_TOP.xCOL20.q20)	= 0v
.ic v(XARRAY_TOP.xCOL20.qb20)	= 0.7v
.ic v(XARRAY_TOP.xCOL21.q20)	= 0v
.ic v(XARRAY_TOP.xCOL21.qb20)	= 0.7v
.ic v(XARRAY_TOP.xCOL22.q20)	= 0v
.ic v(XARRAY_TOP.xCOL22.qb20)	= 0.7v
.ic v(XARRAY_TOP.xCOL23.q20)	= 0v
.ic v(XARRAY_TOP.xCOL23.qb20)	= 0.7v
.ic v(XARRAY_TOP.xCOL24.q20)	= 0v
.ic v(XARRAY_TOP.xCOL24.qb20)	= 0.7v
.ic v(XARRAY_TOP.xCOL25.q20)	= 0v
.ic v(XARRAY_TOP.xCOL25.qb20)	= 0.7v
.ic v(XARRAY_TOP.xCOL26.q20)	= 0v
.ic v(XARRAY_TOP.xCOL26.qb20)	= 0.7v
.ic v(XARRAY_TOP.xCOL27.q20)	= 0v
.ic v(XARRAY_TOP.xCOL27.qb20)	= 0.7v
.ic v(XARRAY_TOP.xCOL28.q20)	= 0v
.ic v(XARRAY_TOP.xCOL28.qb20)	= 0.7v
.ic v(XARRAY_TOP.xCOL29.q20)	= 0v
.ic v(XARRAY_TOP.xCOL29.qb20)	= 0.7v
.ic v(XARRAY_TOP.xCOL30.q20)	= 0v
.ic v(XARRAY_TOP.xCOL30.qb20)	= 0.7v
.ic v(XARRAY_TOP.xCOL31.q20)	= 0v
.ic v(XARRAY_TOP.xCOL31.qb20)	= 0.7v
.ic v(XARRAY_TOP.xCOL0.q21)	= 0v
.ic v(XARRAY_TOP.xCOL0.qb21)	= 0.7v
.ic v(XARRAY_TOP.xCOL1.q21)	= 0v
.ic v(XARRAY_TOP.xCOL1.qb21)	= 0.7v
.ic v(XARRAY_TOP.xCOL2.q21)	= 0v
.ic v(XARRAY_TOP.xCOL2.qb21)	= 0.7v
.ic v(XARRAY_TOP.xCOL3.q21)	= 0v
.ic v(XARRAY_TOP.xCOL3.qb21)	= 0.7v
.ic v(XARRAY_TOP.xCOL4.q21)	= 0v
.ic v(XARRAY_TOP.xCOL4.qb21)	= 0.7v
.ic v(XARRAY_TOP.xCOL5.q21)	= 0v
.ic v(XARRAY_TOP.xCOL5.qb21)	= 0.7v
.ic v(XARRAY_TOP.xCOL6.q21)	= 0v
.ic v(XARRAY_TOP.xCOL6.qb21)	= 0.7v
.ic v(XARRAY_TOP.xCOL7.q21)	= 0v
.ic v(XARRAY_TOP.xCOL7.qb21)	= 0.7v
.ic v(XARRAY_TOP.xCOL8.q21)	= 0v
.ic v(XARRAY_TOP.xCOL8.qb21)	= 0.7v
.ic v(XARRAY_TOP.xCOL9.q21)	= 0v
.ic v(XARRAY_TOP.xCOL9.qb21)	= 0.7v
.ic v(XARRAY_TOP.xCOL10.q21)	= 0v
.ic v(XARRAY_TOP.xCOL10.qb21)	= 0.7v
.ic v(XARRAY_TOP.xCOL11.q21)	= 0v
.ic v(XARRAY_TOP.xCOL11.qb21)	= 0.7v
.ic v(XARRAY_TOP.xCOL12.q21)	= 0v
.ic v(XARRAY_TOP.xCOL12.qb21)	= 0.7v
.ic v(XARRAY_TOP.xCOL13.q21)	= 0v
.ic v(XARRAY_TOP.xCOL13.qb21)	= 0.7v
.ic v(XARRAY_TOP.xCOL14.q21)	= 0v
.ic v(XARRAY_TOP.xCOL14.qb21)	= 0.7v
.ic v(XARRAY_TOP.xCOL15.q21)	= 0v
.ic v(XARRAY_TOP.xCOL15.qb21)	= 0.7v
.ic v(XARRAY_TOP.xCOL16.q21)	= 0v
.ic v(XARRAY_TOP.xCOL16.qb21)	= 0.7v
.ic v(XARRAY_TOP.xCOL17.q21)	= 0v
.ic v(XARRAY_TOP.xCOL17.qb21)	= 0.7v
.ic v(XARRAY_TOP.xCOL18.q21)	= 0v
.ic v(XARRAY_TOP.xCOL18.qb21)	= 0.7v
.ic v(XARRAY_TOP.xCOL19.q21)	= 0v
.ic v(XARRAY_TOP.xCOL19.qb21)	= 0.7v
.ic v(XARRAY_TOP.xCOL20.q21)	= 0v
.ic v(XARRAY_TOP.xCOL20.qb21)	= 0.7v
.ic v(XARRAY_TOP.xCOL21.q21)	= 0v
.ic v(XARRAY_TOP.xCOL21.qb21)	= 0.7v
.ic v(XARRAY_TOP.xCOL22.q21)	= 0v
.ic v(XARRAY_TOP.xCOL22.qb21)	= 0.7v
.ic v(XARRAY_TOP.xCOL23.q21)	= 0v
.ic v(XARRAY_TOP.xCOL23.qb21)	= 0.7v
.ic v(XARRAY_TOP.xCOL24.q21)	= 0v
.ic v(XARRAY_TOP.xCOL24.qb21)	= 0.7v
.ic v(XARRAY_TOP.xCOL25.q21)	= 0v
.ic v(XARRAY_TOP.xCOL25.qb21)	= 0.7v
.ic v(XARRAY_TOP.xCOL26.q21)	= 0v
.ic v(XARRAY_TOP.xCOL26.qb21)	= 0.7v
.ic v(XARRAY_TOP.xCOL27.q21)	= 0v
.ic v(XARRAY_TOP.xCOL27.qb21)	= 0.7v
.ic v(XARRAY_TOP.xCOL28.q21)	= 0v
.ic v(XARRAY_TOP.xCOL28.qb21)	= 0.7v
.ic v(XARRAY_TOP.xCOL29.q21)	= 0v
.ic v(XARRAY_TOP.xCOL29.qb21)	= 0.7v
.ic v(XARRAY_TOP.xCOL30.q21)	= 0v
.ic v(XARRAY_TOP.xCOL30.qb21)	= 0.7v
.ic v(XARRAY_TOP.xCOL31.q21)	= 0v
.ic v(XARRAY_TOP.xCOL31.qb21)	= 0.7v
.ic v(XARRAY_TOP.xCOL0.q22)	= 0v
.ic v(XARRAY_TOP.xCOL0.qb22)	= 0.7v
.ic v(XARRAY_TOP.xCOL1.q22)	= 0v
.ic v(XARRAY_TOP.xCOL1.qb22)	= 0.7v
.ic v(XARRAY_TOP.xCOL2.q22)	= 0v
.ic v(XARRAY_TOP.xCOL2.qb22)	= 0.7v
.ic v(XARRAY_TOP.xCOL3.q22)	= 0v
.ic v(XARRAY_TOP.xCOL3.qb22)	= 0.7v
.ic v(XARRAY_TOP.xCOL4.q22)	= 0v
.ic v(XARRAY_TOP.xCOL4.qb22)	= 0.7v
.ic v(XARRAY_TOP.xCOL5.q22)	= 0v
.ic v(XARRAY_TOP.xCOL5.qb22)	= 0.7v
.ic v(XARRAY_TOP.xCOL6.q22)	= 0v
.ic v(XARRAY_TOP.xCOL6.qb22)	= 0.7v
.ic v(XARRAY_TOP.xCOL7.q22)	= 0v
.ic v(XARRAY_TOP.xCOL7.qb22)	= 0.7v
.ic v(XARRAY_TOP.xCOL8.q22)	= 0v
.ic v(XARRAY_TOP.xCOL8.qb22)	= 0.7v
.ic v(XARRAY_TOP.xCOL9.q22)	= 0v
.ic v(XARRAY_TOP.xCOL9.qb22)	= 0.7v
.ic v(XARRAY_TOP.xCOL10.q22)	= 0v
.ic v(XARRAY_TOP.xCOL10.qb22)	= 0.7v
.ic v(XARRAY_TOP.xCOL11.q22)	= 0v
.ic v(XARRAY_TOP.xCOL11.qb22)	= 0.7v
.ic v(XARRAY_TOP.xCOL12.q22)	= 0v
.ic v(XARRAY_TOP.xCOL12.qb22)	= 0.7v
.ic v(XARRAY_TOP.xCOL13.q22)	= 0v
.ic v(XARRAY_TOP.xCOL13.qb22)	= 0.7v
.ic v(XARRAY_TOP.xCOL14.q22)	= 0v
.ic v(XARRAY_TOP.xCOL14.qb22)	= 0.7v
.ic v(XARRAY_TOP.xCOL15.q22)	= 0v
.ic v(XARRAY_TOP.xCOL15.qb22)	= 0.7v
.ic v(XARRAY_TOP.xCOL16.q22)	= 0v
.ic v(XARRAY_TOP.xCOL16.qb22)	= 0.7v
.ic v(XARRAY_TOP.xCOL17.q22)	= 0v
.ic v(XARRAY_TOP.xCOL17.qb22)	= 0.7v
.ic v(XARRAY_TOP.xCOL18.q22)	= 0v
.ic v(XARRAY_TOP.xCOL18.qb22)	= 0.7v
.ic v(XARRAY_TOP.xCOL19.q22)	= 0v
.ic v(XARRAY_TOP.xCOL19.qb22)	= 0.7v
.ic v(XARRAY_TOP.xCOL20.q22)	= 0v
.ic v(XARRAY_TOP.xCOL20.qb22)	= 0.7v
.ic v(XARRAY_TOP.xCOL21.q22)	= 0v
.ic v(XARRAY_TOP.xCOL21.qb22)	= 0.7v
.ic v(XARRAY_TOP.xCOL22.q22)	= 0v
.ic v(XARRAY_TOP.xCOL22.qb22)	= 0.7v
.ic v(XARRAY_TOP.xCOL23.q22)	= 0v
.ic v(XARRAY_TOP.xCOL23.qb22)	= 0.7v
.ic v(XARRAY_TOP.xCOL24.q22)	= 0v
.ic v(XARRAY_TOP.xCOL24.qb22)	= 0.7v
.ic v(XARRAY_TOP.xCOL25.q22)	= 0v
.ic v(XARRAY_TOP.xCOL25.qb22)	= 0.7v
.ic v(XARRAY_TOP.xCOL26.q22)	= 0v
.ic v(XARRAY_TOP.xCOL26.qb22)	= 0.7v
.ic v(XARRAY_TOP.xCOL27.q22)	= 0v
.ic v(XARRAY_TOP.xCOL27.qb22)	= 0.7v
.ic v(XARRAY_TOP.xCOL28.q22)	= 0v
.ic v(XARRAY_TOP.xCOL28.qb22)	= 0.7v
.ic v(XARRAY_TOP.xCOL29.q22)	= 0v
.ic v(XARRAY_TOP.xCOL29.qb22)	= 0.7v
.ic v(XARRAY_TOP.xCOL30.q22)	= 0v
.ic v(XARRAY_TOP.xCOL30.qb22)	= 0.7v
.ic v(XARRAY_TOP.xCOL31.q22)	= 0v
.ic v(XARRAY_TOP.xCOL31.qb22)	= 0.7v
.ic v(XARRAY_TOP.xCOL0.q23)	= 0v
.ic v(XARRAY_TOP.xCOL0.qb23)	= 0.7v
.ic v(XARRAY_TOP.xCOL1.q23)	= 0v
.ic v(XARRAY_TOP.xCOL1.qb23)	= 0.7v
.ic v(XARRAY_TOP.xCOL2.q23)	= 0v
.ic v(XARRAY_TOP.xCOL2.qb23)	= 0.7v
.ic v(XARRAY_TOP.xCOL3.q23)	= 0v
.ic v(XARRAY_TOP.xCOL3.qb23)	= 0.7v
.ic v(XARRAY_TOP.xCOL4.q23)	= 0v
.ic v(XARRAY_TOP.xCOL4.qb23)	= 0.7v
.ic v(XARRAY_TOP.xCOL5.q23)	= 0v
.ic v(XARRAY_TOP.xCOL5.qb23)	= 0.7v
.ic v(XARRAY_TOP.xCOL6.q23)	= 0v
.ic v(XARRAY_TOP.xCOL6.qb23)	= 0.7v
.ic v(XARRAY_TOP.xCOL7.q23)	= 0v
.ic v(XARRAY_TOP.xCOL7.qb23)	= 0.7v
.ic v(XARRAY_TOP.xCOL8.q23)	= 0v
.ic v(XARRAY_TOP.xCOL8.qb23)	= 0.7v
.ic v(XARRAY_TOP.xCOL9.q23)	= 0v
.ic v(XARRAY_TOP.xCOL9.qb23)	= 0.7v
.ic v(XARRAY_TOP.xCOL10.q23)	= 0v
.ic v(XARRAY_TOP.xCOL10.qb23)	= 0.7v
.ic v(XARRAY_TOP.xCOL11.q23)	= 0v
.ic v(XARRAY_TOP.xCOL11.qb23)	= 0.7v
.ic v(XARRAY_TOP.xCOL12.q23)	= 0v
.ic v(XARRAY_TOP.xCOL12.qb23)	= 0.7v
.ic v(XARRAY_TOP.xCOL13.q23)	= 0v
.ic v(XARRAY_TOP.xCOL13.qb23)	= 0.7v
.ic v(XARRAY_TOP.xCOL14.q23)	= 0v
.ic v(XARRAY_TOP.xCOL14.qb23)	= 0.7v
.ic v(XARRAY_TOP.xCOL15.q23)	= 0v
.ic v(XARRAY_TOP.xCOL15.qb23)	= 0.7v
.ic v(XARRAY_TOP.xCOL16.q23)	= 0v
.ic v(XARRAY_TOP.xCOL16.qb23)	= 0.7v
.ic v(XARRAY_TOP.xCOL17.q23)	= 0v
.ic v(XARRAY_TOP.xCOL17.qb23)	= 0.7v
.ic v(XARRAY_TOP.xCOL18.q23)	= 0v
.ic v(XARRAY_TOP.xCOL18.qb23)	= 0.7v
.ic v(XARRAY_TOP.xCOL19.q23)	= 0v
.ic v(XARRAY_TOP.xCOL19.qb23)	= 0.7v
.ic v(XARRAY_TOP.xCOL20.q23)	= 0v
.ic v(XARRAY_TOP.xCOL20.qb23)	= 0.7v
.ic v(XARRAY_TOP.xCOL21.q23)	= 0v
.ic v(XARRAY_TOP.xCOL21.qb23)	= 0.7v
.ic v(XARRAY_TOP.xCOL22.q23)	= 0v
.ic v(XARRAY_TOP.xCOL22.qb23)	= 0.7v
.ic v(XARRAY_TOP.xCOL23.q23)	= 0v
.ic v(XARRAY_TOP.xCOL23.qb23)	= 0.7v
.ic v(XARRAY_TOP.xCOL24.q23)	= 0v
.ic v(XARRAY_TOP.xCOL24.qb23)	= 0.7v
.ic v(XARRAY_TOP.xCOL25.q23)	= 0v
.ic v(XARRAY_TOP.xCOL25.qb23)	= 0.7v
.ic v(XARRAY_TOP.xCOL26.q23)	= 0v
.ic v(XARRAY_TOP.xCOL26.qb23)	= 0.7v
.ic v(XARRAY_TOP.xCOL27.q23)	= 0v
.ic v(XARRAY_TOP.xCOL27.qb23)	= 0.7v
.ic v(XARRAY_TOP.xCOL28.q23)	= 0v
.ic v(XARRAY_TOP.xCOL28.qb23)	= 0.7v
.ic v(XARRAY_TOP.xCOL29.q23)	= 0v
.ic v(XARRAY_TOP.xCOL29.qb23)	= 0.7v
.ic v(XARRAY_TOP.xCOL30.q23)	= 0v
.ic v(XARRAY_TOP.xCOL30.qb23)	= 0.7v
.ic v(XARRAY_TOP.xCOL31.q23)	= 0v
.ic v(XARRAY_TOP.xCOL31.qb23)	= 0.7v
.ic v(XARRAY_TOP.xCOL0.q24)	= 0v
.ic v(XARRAY_TOP.xCOL0.qb24)	= 0.7v
.ic v(XARRAY_TOP.xCOL1.q24)	= 0v
.ic v(XARRAY_TOP.xCOL1.qb24)	= 0.7v
.ic v(XARRAY_TOP.xCOL2.q24)	= 0v
.ic v(XARRAY_TOP.xCOL2.qb24)	= 0.7v
.ic v(XARRAY_TOP.xCOL3.q24)	= 0v
.ic v(XARRAY_TOP.xCOL3.qb24)	= 0.7v
.ic v(XARRAY_TOP.xCOL4.q24)	= 0v
.ic v(XARRAY_TOP.xCOL4.qb24)	= 0.7v
.ic v(XARRAY_TOP.xCOL5.q24)	= 0v
.ic v(XARRAY_TOP.xCOL5.qb24)	= 0.7v
.ic v(XARRAY_TOP.xCOL6.q24)	= 0v
.ic v(XARRAY_TOP.xCOL6.qb24)	= 0.7v
.ic v(XARRAY_TOP.xCOL7.q24)	= 0v
.ic v(XARRAY_TOP.xCOL7.qb24)	= 0.7v
.ic v(XARRAY_TOP.xCOL8.q24)	= 0v
.ic v(XARRAY_TOP.xCOL8.qb24)	= 0.7v
.ic v(XARRAY_TOP.xCOL9.q24)	= 0v
.ic v(XARRAY_TOP.xCOL9.qb24)	= 0.7v
.ic v(XARRAY_TOP.xCOL10.q24)	= 0v
.ic v(XARRAY_TOP.xCOL10.qb24)	= 0.7v
.ic v(XARRAY_TOP.xCOL11.q24)	= 0v
.ic v(XARRAY_TOP.xCOL11.qb24)	= 0.7v
.ic v(XARRAY_TOP.xCOL12.q24)	= 0v
.ic v(XARRAY_TOP.xCOL12.qb24)	= 0.7v
.ic v(XARRAY_TOP.xCOL13.q24)	= 0v
.ic v(XARRAY_TOP.xCOL13.qb24)	= 0.7v
.ic v(XARRAY_TOP.xCOL14.q24)	= 0v
.ic v(XARRAY_TOP.xCOL14.qb24)	= 0.7v
.ic v(XARRAY_TOP.xCOL15.q24)	= 0v
.ic v(XARRAY_TOP.xCOL15.qb24)	= 0.7v
.ic v(XARRAY_TOP.xCOL16.q24)	= 0v
.ic v(XARRAY_TOP.xCOL16.qb24)	= 0.7v
.ic v(XARRAY_TOP.xCOL17.q24)	= 0v
.ic v(XARRAY_TOP.xCOL17.qb24)	= 0.7v
.ic v(XARRAY_TOP.xCOL18.q24)	= 0v
.ic v(XARRAY_TOP.xCOL18.qb24)	= 0.7v
.ic v(XARRAY_TOP.xCOL19.q24)	= 0v
.ic v(XARRAY_TOP.xCOL19.qb24)	= 0.7v
.ic v(XARRAY_TOP.xCOL20.q24)	= 0v
.ic v(XARRAY_TOP.xCOL20.qb24)	= 0.7v
.ic v(XARRAY_TOP.xCOL21.q24)	= 0v
.ic v(XARRAY_TOP.xCOL21.qb24)	= 0.7v
.ic v(XARRAY_TOP.xCOL22.q24)	= 0v
.ic v(XARRAY_TOP.xCOL22.qb24)	= 0.7v
.ic v(XARRAY_TOP.xCOL23.q24)	= 0v
.ic v(XARRAY_TOP.xCOL23.qb24)	= 0.7v
.ic v(XARRAY_TOP.xCOL24.q24)	= 0v
.ic v(XARRAY_TOP.xCOL24.qb24)	= 0.7v
.ic v(XARRAY_TOP.xCOL25.q24)	= 0v
.ic v(XARRAY_TOP.xCOL25.qb24)	= 0.7v
.ic v(XARRAY_TOP.xCOL26.q24)	= 0v
.ic v(XARRAY_TOP.xCOL26.qb24)	= 0.7v
.ic v(XARRAY_TOP.xCOL27.q24)	= 0v
.ic v(XARRAY_TOP.xCOL27.qb24)	= 0.7v
.ic v(XARRAY_TOP.xCOL28.q24)	= 0v
.ic v(XARRAY_TOP.xCOL28.qb24)	= 0.7v
.ic v(XARRAY_TOP.xCOL29.q24)	= 0v
.ic v(XARRAY_TOP.xCOL29.qb24)	= 0.7v
.ic v(XARRAY_TOP.xCOL30.q24)	= 0v
.ic v(XARRAY_TOP.xCOL30.qb24)	= 0.7v
.ic v(XARRAY_TOP.xCOL31.q24)	= 0v
.ic v(XARRAY_TOP.xCOL31.qb24)	= 0.7v
.ic v(XARRAY_TOP.xCOL0.q25)	= 0v
.ic v(XARRAY_TOP.xCOL0.qb25)	= 0.7v
.ic v(XARRAY_TOP.xCOL1.q25)	= 0v
.ic v(XARRAY_TOP.xCOL1.qb25)	= 0.7v
.ic v(XARRAY_TOP.xCOL2.q25)	= 0v
.ic v(XARRAY_TOP.xCOL2.qb25)	= 0.7v
.ic v(XARRAY_TOP.xCOL3.q25)	= 0v
.ic v(XARRAY_TOP.xCOL3.qb25)	= 0.7v
.ic v(XARRAY_TOP.xCOL4.q25)	= 0v
.ic v(XARRAY_TOP.xCOL4.qb25)	= 0.7v
.ic v(XARRAY_TOP.xCOL5.q25)	= 0v
.ic v(XARRAY_TOP.xCOL5.qb25)	= 0.7v
.ic v(XARRAY_TOP.xCOL6.q25)	= 0v
.ic v(XARRAY_TOP.xCOL6.qb25)	= 0.7v
.ic v(XARRAY_TOP.xCOL7.q25)	= 0v
.ic v(XARRAY_TOP.xCOL7.qb25)	= 0.7v
.ic v(XARRAY_TOP.xCOL8.q25)	= 0v
.ic v(XARRAY_TOP.xCOL8.qb25)	= 0.7v
.ic v(XARRAY_TOP.xCOL9.q25)	= 0v
.ic v(XARRAY_TOP.xCOL9.qb25)	= 0.7v
.ic v(XARRAY_TOP.xCOL10.q25)	= 0v
.ic v(XARRAY_TOP.xCOL10.qb25)	= 0.7v
.ic v(XARRAY_TOP.xCOL11.q25)	= 0v
.ic v(XARRAY_TOP.xCOL11.qb25)	= 0.7v
.ic v(XARRAY_TOP.xCOL12.q25)	= 0v
.ic v(XARRAY_TOP.xCOL12.qb25)	= 0.7v
.ic v(XARRAY_TOP.xCOL13.q25)	= 0v
.ic v(XARRAY_TOP.xCOL13.qb25)	= 0.7v
.ic v(XARRAY_TOP.xCOL14.q25)	= 0v
.ic v(XARRAY_TOP.xCOL14.qb25)	= 0.7v
.ic v(XARRAY_TOP.xCOL15.q25)	= 0v
.ic v(XARRAY_TOP.xCOL15.qb25)	= 0.7v
.ic v(XARRAY_TOP.xCOL16.q25)	= 0v
.ic v(XARRAY_TOP.xCOL16.qb25)	= 0.7v
.ic v(XARRAY_TOP.xCOL17.q25)	= 0v
.ic v(XARRAY_TOP.xCOL17.qb25)	= 0.7v
.ic v(XARRAY_TOP.xCOL18.q25)	= 0v
.ic v(XARRAY_TOP.xCOL18.qb25)	= 0.7v
.ic v(XARRAY_TOP.xCOL19.q25)	= 0v
.ic v(XARRAY_TOP.xCOL19.qb25)	= 0.7v
.ic v(XARRAY_TOP.xCOL20.q25)	= 0v
.ic v(XARRAY_TOP.xCOL20.qb25)	= 0.7v
.ic v(XARRAY_TOP.xCOL21.q25)	= 0v
.ic v(XARRAY_TOP.xCOL21.qb25)	= 0.7v
.ic v(XARRAY_TOP.xCOL22.q25)	= 0v
.ic v(XARRAY_TOP.xCOL22.qb25)	= 0.7v
.ic v(XARRAY_TOP.xCOL23.q25)	= 0v
.ic v(XARRAY_TOP.xCOL23.qb25)	= 0.7v
.ic v(XARRAY_TOP.xCOL24.q25)	= 0v
.ic v(XARRAY_TOP.xCOL24.qb25)	= 0.7v
.ic v(XARRAY_TOP.xCOL25.q25)	= 0v
.ic v(XARRAY_TOP.xCOL25.qb25)	= 0.7v
.ic v(XARRAY_TOP.xCOL26.q25)	= 0v
.ic v(XARRAY_TOP.xCOL26.qb25)	= 0.7v
.ic v(XARRAY_TOP.xCOL27.q25)	= 0v
.ic v(XARRAY_TOP.xCOL27.qb25)	= 0.7v
.ic v(XARRAY_TOP.xCOL28.q25)	= 0v
.ic v(XARRAY_TOP.xCOL28.qb25)	= 0.7v
.ic v(XARRAY_TOP.xCOL29.q25)	= 0v
.ic v(XARRAY_TOP.xCOL29.qb25)	= 0.7v
.ic v(XARRAY_TOP.xCOL30.q25)	= 0v
.ic v(XARRAY_TOP.xCOL30.qb25)	= 0.7v
.ic v(XARRAY_TOP.xCOL31.q25)	= 0v
.ic v(XARRAY_TOP.xCOL31.qb25)	= 0.7v
.ic v(XARRAY_TOP.xCOL0.q26)	= 0v
.ic v(XARRAY_TOP.xCOL0.qb26)	= 0.7v
.ic v(XARRAY_TOP.xCOL1.q26)	= 0v
.ic v(XARRAY_TOP.xCOL1.qb26)	= 0.7v
.ic v(XARRAY_TOP.xCOL2.q26)	= 0v
.ic v(XARRAY_TOP.xCOL2.qb26)	= 0.7v
.ic v(XARRAY_TOP.xCOL3.q26)	= 0v
.ic v(XARRAY_TOP.xCOL3.qb26)	= 0.7v
.ic v(XARRAY_TOP.xCOL4.q26)	= 0v
.ic v(XARRAY_TOP.xCOL4.qb26)	= 0.7v
.ic v(XARRAY_TOP.xCOL5.q26)	= 0v
.ic v(XARRAY_TOP.xCOL5.qb26)	= 0.7v
.ic v(XARRAY_TOP.xCOL6.q26)	= 0v
.ic v(XARRAY_TOP.xCOL6.qb26)	= 0.7v
.ic v(XARRAY_TOP.xCOL7.q26)	= 0v
.ic v(XARRAY_TOP.xCOL7.qb26)	= 0.7v
.ic v(XARRAY_TOP.xCOL8.q26)	= 0v
.ic v(XARRAY_TOP.xCOL8.qb26)	= 0.7v
.ic v(XARRAY_TOP.xCOL9.q26)	= 0v
.ic v(XARRAY_TOP.xCOL9.qb26)	= 0.7v
.ic v(XARRAY_TOP.xCOL10.q26)	= 0v
.ic v(XARRAY_TOP.xCOL10.qb26)	= 0.7v
.ic v(XARRAY_TOP.xCOL11.q26)	= 0v
.ic v(XARRAY_TOP.xCOL11.qb26)	= 0.7v
.ic v(XARRAY_TOP.xCOL12.q26)	= 0v
.ic v(XARRAY_TOP.xCOL12.qb26)	= 0.7v
.ic v(XARRAY_TOP.xCOL13.q26)	= 0v
.ic v(XARRAY_TOP.xCOL13.qb26)	= 0.7v
.ic v(XARRAY_TOP.xCOL14.q26)	= 0v
.ic v(XARRAY_TOP.xCOL14.qb26)	= 0.7v
.ic v(XARRAY_TOP.xCOL15.q26)	= 0v
.ic v(XARRAY_TOP.xCOL15.qb26)	= 0.7v
.ic v(XARRAY_TOP.xCOL16.q26)	= 0v
.ic v(XARRAY_TOP.xCOL16.qb26)	= 0.7v
.ic v(XARRAY_TOP.xCOL17.q26)	= 0v
.ic v(XARRAY_TOP.xCOL17.qb26)	= 0.7v
.ic v(XARRAY_TOP.xCOL18.q26)	= 0v
.ic v(XARRAY_TOP.xCOL18.qb26)	= 0.7v
.ic v(XARRAY_TOP.xCOL19.q26)	= 0v
.ic v(XARRAY_TOP.xCOL19.qb26)	= 0.7v
.ic v(XARRAY_TOP.xCOL20.q26)	= 0v
.ic v(XARRAY_TOP.xCOL20.qb26)	= 0.7v
.ic v(XARRAY_TOP.xCOL21.q26)	= 0v
.ic v(XARRAY_TOP.xCOL21.qb26)	= 0.7v
.ic v(XARRAY_TOP.xCOL22.q26)	= 0v
.ic v(XARRAY_TOP.xCOL22.qb26)	= 0.7v
.ic v(XARRAY_TOP.xCOL23.q26)	= 0v
.ic v(XARRAY_TOP.xCOL23.qb26)	= 0.7v
.ic v(XARRAY_TOP.xCOL24.q26)	= 0v
.ic v(XARRAY_TOP.xCOL24.qb26)	= 0.7v
.ic v(XARRAY_TOP.xCOL25.q26)	= 0v
.ic v(XARRAY_TOP.xCOL25.qb26)	= 0.7v
.ic v(XARRAY_TOP.xCOL26.q26)	= 0v
.ic v(XARRAY_TOP.xCOL26.qb26)	= 0.7v
.ic v(XARRAY_TOP.xCOL27.q26)	= 0v
.ic v(XARRAY_TOP.xCOL27.qb26)	= 0.7v
.ic v(XARRAY_TOP.xCOL28.q26)	= 0v
.ic v(XARRAY_TOP.xCOL28.qb26)	= 0.7v
.ic v(XARRAY_TOP.xCOL29.q26)	= 0v
.ic v(XARRAY_TOP.xCOL29.qb26)	= 0.7v
.ic v(XARRAY_TOP.xCOL30.q26)	= 0v
.ic v(XARRAY_TOP.xCOL30.qb26)	= 0.7v
.ic v(XARRAY_TOP.xCOL31.q26)	= 0v
.ic v(XARRAY_TOP.xCOL31.qb26)	= 0.7v
.ic v(XARRAY_TOP.xCOL0.q27)	= 0v
.ic v(XARRAY_TOP.xCOL0.qb27)	= 0.7v
.ic v(XARRAY_TOP.xCOL1.q27)	= 0v
.ic v(XARRAY_TOP.xCOL1.qb27)	= 0.7v
.ic v(XARRAY_TOP.xCOL2.q27)	= 0v
.ic v(XARRAY_TOP.xCOL2.qb27)	= 0.7v
.ic v(XARRAY_TOP.xCOL3.q27)	= 0v
.ic v(XARRAY_TOP.xCOL3.qb27)	= 0.7v
.ic v(XARRAY_TOP.xCOL4.q27)	= 0v
.ic v(XARRAY_TOP.xCOL4.qb27)	= 0.7v
.ic v(XARRAY_TOP.xCOL5.q27)	= 0v
.ic v(XARRAY_TOP.xCOL5.qb27)	= 0.7v
.ic v(XARRAY_TOP.xCOL6.q27)	= 0v
.ic v(XARRAY_TOP.xCOL6.qb27)	= 0.7v
.ic v(XARRAY_TOP.xCOL7.q27)	= 0v
.ic v(XARRAY_TOP.xCOL7.qb27)	= 0.7v
.ic v(XARRAY_TOP.xCOL8.q27)	= 0v
.ic v(XARRAY_TOP.xCOL8.qb27)	= 0.7v
.ic v(XARRAY_TOP.xCOL9.q27)	= 0v
.ic v(XARRAY_TOP.xCOL9.qb27)	= 0.7v
.ic v(XARRAY_TOP.xCOL10.q27)	= 0v
.ic v(XARRAY_TOP.xCOL10.qb27)	= 0.7v
.ic v(XARRAY_TOP.xCOL11.q27)	= 0v
.ic v(XARRAY_TOP.xCOL11.qb27)	= 0.7v
.ic v(XARRAY_TOP.xCOL12.q27)	= 0v
.ic v(XARRAY_TOP.xCOL12.qb27)	= 0.7v
.ic v(XARRAY_TOP.xCOL13.q27)	= 0v
.ic v(XARRAY_TOP.xCOL13.qb27)	= 0.7v
.ic v(XARRAY_TOP.xCOL14.q27)	= 0v
.ic v(XARRAY_TOP.xCOL14.qb27)	= 0.7v
.ic v(XARRAY_TOP.xCOL15.q27)	= 0v
.ic v(XARRAY_TOP.xCOL15.qb27)	= 0.7v
.ic v(XARRAY_TOP.xCOL16.q27)	= 0v
.ic v(XARRAY_TOP.xCOL16.qb27)	= 0.7v
.ic v(XARRAY_TOP.xCOL17.q27)	= 0v
.ic v(XARRAY_TOP.xCOL17.qb27)	= 0.7v
.ic v(XARRAY_TOP.xCOL18.q27)	= 0v
.ic v(XARRAY_TOP.xCOL18.qb27)	= 0.7v
.ic v(XARRAY_TOP.xCOL19.q27)	= 0v
.ic v(XARRAY_TOP.xCOL19.qb27)	= 0.7v
.ic v(XARRAY_TOP.xCOL20.q27)	= 0v
.ic v(XARRAY_TOP.xCOL20.qb27)	= 0.7v
.ic v(XARRAY_TOP.xCOL21.q27)	= 0v
.ic v(XARRAY_TOP.xCOL21.qb27)	= 0.7v
.ic v(XARRAY_TOP.xCOL22.q27)	= 0v
.ic v(XARRAY_TOP.xCOL22.qb27)	= 0.7v
.ic v(XARRAY_TOP.xCOL23.q27)	= 0v
.ic v(XARRAY_TOP.xCOL23.qb27)	= 0.7v
.ic v(XARRAY_TOP.xCOL24.q27)	= 0v
.ic v(XARRAY_TOP.xCOL24.qb27)	= 0.7v
.ic v(XARRAY_TOP.xCOL25.q27)	= 0v
.ic v(XARRAY_TOP.xCOL25.qb27)	= 0.7v
.ic v(XARRAY_TOP.xCOL26.q27)	= 0v
.ic v(XARRAY_TOP.xCOL26.qb27)	= 0.7v
.ic v(XARRAY_TOP.xCOL27.q27)	= 0v
.ic v(XARRAY_TOP.xCOL27.qb27)	= 0.7v
.ic v(XARRAY_TOP.xCOL28.q27)	= 0v
.ic v(XARRAY_TOP.xCOL28.qb27)	= 0.7v
.ic v(XARRAY_TOP.xCOL29.q27)	= 0v
.ic v(XARRAY_TOP.xCOL29.qb27)	= 0.7v
.ic v(XARRAY_TOP.xCOL30.q27)	= 0v
.ic v(XARRAY_TOP.xCOL30.qb27)	= 0.7v
.ic v(XARRAY_TOP.xCOL31.q27)	= 0v
.ic v(XARRAY_TOP.xCOL31.qb27)	= 0.7v
.ic v(XARRAY_TOP.xCOL0.q28)	= 0v
.ic v(XARRAY_TOP.xCOL0.qb28)	= 0.7v
.ic v(XARRAY_TOP.xCOL1.q28)	= 0v
.ic v(XARRAY_TOP.xCOL1.qb28)	= 0.7v
.ic v(XARRAY_TOP.xCOL2.q28)	= 0v
.ic v(XARRAY_TOP.xCOL2.qb28)	= 0.7v
.ic v(XARRAY_TOP.xCOL3.q28)	= 0v
.ic v(XARRAY_TOP.xCOL3.qb28)	= 0.7v
.ic v(XARRAY_TOP.xCOL4.q28)	= 0v
.ic v(XARRAY_TOP.xCOL4.qb28)	= 0.7v
.ic v(XARRAY_TOP.xCOL5.q28)	= 0v
.ic v(XARRAY_TOP.xCOL5.qb28)	= 0.7v
.ic v(XARRAY_TOP.xCOL6.q28)	= 0v
.ic v(XARRAY_TOP.xCOL6.qb28)	= 0.7v
.ic v(XARRAY_TOP.xCOL7.q28)	= 0v
.ic v(XARRAY_TOP.xCOL7.qb28)	= 0.7v
.ic v(XARRAY_TOP.xCOL8.q28)	= 0v
.ic v(XARRAY_TOP.xCOL8.qb28)	= 0.7v
.ic v(XARRAY_TOP.xCOL9.q28)	= 0v
.ic v(XARRAY_TOP.xCOL9.qb28)	= 0.7v
.ic v(XARRAY_TOP.xCOL10.q28)	= 0v
.ic v(XARRAY_TOP.xCOL10.qb28)	= 0.7v
.ic v(XARRAY_TOP.xCOL11.q28)	= 0v
.ic v(XARRAY_TOP.xCOL11.qb28)	= 0.7v
.ic v(XARRAY_TOP.xCOL12.q28)	= 0v
.ic v(XARRAY_TOP.xCOL12.qb28)	= 0.7v
.ic v(XARRAY_TOP.xCOL13.q28)	= 0v
.ic v(XARRAY_TOP.xCOL13.qb28)	= 0.7v
.ic v(XARRAY_TOP.xCOL14.q28)	= 0v
.ic v(XARRAY_TOP.xCOL14.qb28)	= 0.7v
.ic v(XARRAY_TOP.xCOL15.q28)	= 0v
.ic v(XARRAY_TOP.xCOL15.qb28)	= 0.7v
.ic v(XARRAY_TOP.xCOL16.q28)	= 0v
.ic v(XARRAY_TOP.xCOL16.qb28)	= 0.7v
.ic v(XARRAY_TOP.xCOL17.q28)	= 0v
.ic v(XARRAY_TOP.xCOL17.qb28)	= 0.7v
.ic v(XARRAY_TOP.xCOL18.q28)	= 0v
.ic v(XARRAY_TOP.xCOL18.qb28)	= 0.7v
.ic v(XARRAY_TOP.xCOL19.q28)	= 0v
.ic v(XARRAY_TOP.xCOL19.qb28)	= 0.7v
.ic v(XARRAY_TOP.xCOL20.q28)	= 0v
.ic v(XARRAY_TOP.xCOL20.qb28)	= 0.7v
.ic v(XARRAY_TOP.xCOL21.q28)	= 0v
.ic v(XARRAY_TOP.xCOL21.qb28)	= 0.7v
.ic v(XARRAY_TOP.xCOL22.q28)	= 0v
.ic v(XARRAY_TOP.xCOL22.qb28)	= 0.7v
.ic v(XARRAY_TOP.xCOL23.q28)	= 0v
.ic v(XARRAY_TOP.xCOL23.qb28)	= 0.7v
.ic v(XARRAY_TOP.xCOL24.q28)	= 0v
.ic v(XARRAY_TOP.xCOL24.qb28)	= 0.7v
.ic v(XARRAY_TOP.xCOL25.q28)	= 0v
.ic v(XARRAY_TOP.xCOL25.qb28)	= 0.7v
.ic v(XARRAY_TOP.xCOL26.q28)	= 0v
.ic v(XARRAY_TOP.xCOL26.qb28)	= 0.7v
.ic v(XARRAY_TOP.xCOL27.q28)	= 0v
.ic v(XARRAY_TOP.xCOL27.qb28)	= 0.7v
.ic v(XARRAY_TOP.xCOL28.q28)	= 0v
.ic v(XARRAY_TOP.xCOL28.qb28)	= 0.7v
.ic v(XARRAY_TOP.xCOL29.q28)	= 0v
.ic v(XARRAY_TOP.xCOL29.qb28)	= 0.7v
.ic v(XARRAY_TOP.xCOL30.q28)	= 0v
.ic v(XARRAY_TOP.xCOL30.qb28)	= 0.7v
.ic v(XARRAY_TOP.xCOL31.q28)	= 0v
.ic v(XARRAY_TOP.xCOL31.qb28)	= 0.7v
.ic v(XARRAY_TOP.xCOL0.q29)	= 0v
.ic v(XARRAY_TOP.xCOL0.qb29)	= 0.7v
.ic v(XARRAY_TOP.xCOL1.q29)	= 0v
.ic v(XARRAY_TOP.xCOL1.qb29)	= 0.7v
.ic v(XARRAY_TOP.xCOL2.q29)	= 0v
.ic v(XARRAY_TOP.xCOL2.qb29)	= 0.7v
.ic v(XARRAY_TOP.xCOL3.q29)	= 0v
.ic v(XARRAY_TOP.xCOL3.qb29)	= 0.7v
.ic v(XARRAY_TOP.xCOL4.q29)	= 0v
.ic v(XARRAY_TOP.xCOL4.qb29)	= 0.7v
.ic v(XARRAY_TOP.xCOL5.q29)	= 0v
.ic v(XARRAY_TOP.xCOL5.qb29)	= 0.7v
.ic v(XARRAY_TOP.xCOL6.q29)	= 0v
.ic v(XARRAY_TOP.xCOL6.qb29)	= 0.7v
.ic v(XARRAY_TOP.xCOL7.q29)	= 0v
.ic v(XARRAY_TOP.xCOL7.qb29)	= 0.7v
.ic v(XARRAY_TOP.xCOL8.q29)	= 0v
.ic v(XARRAY_TOP.xCOL8.qb29)	= 0.7v
.ic v(XARRAY_TOP.xCOL9.q29)	= 0v
.ic v(XARRAY_TOP.xCOL9.qb29)	= 0.7v
.ic v(XARRAY_TOP.xCOL10.q29)	= 0v
.ic v(XARRAY_TOP.xCOL10.qb29)	= 0.7v
.ic v(XARRAY_TOP.xCOL11.q29)	= 0v
.ic v(XARRAY_TOP.xCOL11.qb29)	= 0.7v
.ic v(XARRAY_TOP.xCOL12.q29)	= 0v
.ic v(XARRAY_TOP.xCOL12.qb29)	= 0.7v
.ic v(XARRAY_TOP.xCOL13.q29)	= 0v
.ic v(XARRAY_TOP.xCOL13.qb29)	= 0.7v
.ic v(XARRAY_TOP.xCOL14.q29)	= 0v
.ic v(XARRAY_TOP.xCOL14.qb29)	= 0.7v
.ic v(XARRAY_TOP.xCOL15.q29)	= 0v
.ic v(XARRAY_TOP.xCOL15.qb29)	= 0.7v
.ic v(XARRAY_TOP.xCOL16.q29)	= 0v
.ic v(XARRAY_TOP.xCOL16.qb29)	= 0.7v
.ic v(XARRAY_TOP.xCOL17.q29)	= 0v
.ic v(XARRAY_TOP.xCOL17.qb29)	= 0.7v
.ic v(XARRAY_TOP.xCOL18.q29)	= 0v
.ic v(XARRAY_TOP.xCOL18.qb29)	= 0.7v
.ic v(XARRAY_TOP.xCOL19.q29)	= 0v
.ic v(XARRAY_TOP.xCOL19.qb29)	= 0.7v
.ic v(XARRAY_TOP.xCOL20.q29)	= 0v
.ic v(XARRAY_TOP.xCOL20.qb29)	= 0.7v
.ic v(XARRAY_TOP.xCOL21.q29)	= 0v
.ic v(XARRAY_TOP.xCOL21.qb29)	= 0.7v
.ic v(XARRAY_TOP.xCOL22.q29)	= 0v
.ic v(XARRAY_TOP.xCOL22.qb29)	= 0.7v
.ic v(XARRAY_TOP.xCOL23.q29)	= 0v
.ic v(XARRAY_TOP.xCOL23.qb29)	= 0.7v
.ic v(XARRAY_TOP.xCOL24.q29)	= 0v
.ic v(XARRAY_TOP.xCOL24.qb29)	= 0.7v
.ic v(XARRAY_TOP.xCOL25.q29)	= 0v
.ic v(XARRAY_TOP.xCOL25.qb29)	= 0.7v
.ic v(XARRAY_TOP.xCOL26.q29)	= 0v
.ic v(XARRAY_TOP.xCOL26.qb29)	= 0.7v
.ic v(XARRAY_TOP.xCOL27.q29)	= 0v
.ic v(XARRAY_TOP.xCOL27.qb29)	= 0.7v
.ic v(XARRAY_TOP.xCOL28.q29)	= 0v
.ic v(XARRAY_TOP.xCOL28.qb29)	= 0.7v
.ic v(XARRAY_TOP.xCOL29.q29)	= 0v
.ic v(XARRAY_TOP.xCOL29.qb29)	= 0.7v
.ic v(XARRAY_TOP.xCOL30.q29)	= 0v
.ic v(XARRAY_TOP.xCOL30.qb29)	= 0.7v
.ic v(XARRAY_TOP.xCOL31.q29)	= 0v
.ic v(XARRAY_TOP.xCOL31.qb29)	= 0.7v
.ic v(XARRAY_TOP.xCOL0.q30)	= 0v
.ic v(XARRAY_TOP.xCOL0.qb30)	= 0.7v
.ic v(XARRAY_TOP.xCOL1.q30)	= 0v
.ic v(XARRAY_TOP.xCOL1.qb30)	= 0.7v
.ic v(XARRAY_TOP.xCOL2.q30)	= 0v
.ic v(XARRAY_TOP.xCOL2.qb30)	= 0.7v
.ic v(XARRAY_TOP.xCOL3.q30)	= 0v
.ic v(XARRAY_TOP.xCOL3.qb30)	= 0.7v
.ic v(XARRAY_TOP.xCOL4.q30)	= 0v
.ic v(XARRAY_TOP.xCOL4.qb30)	= 0.7v
.ic v(XARRAY_TOP.xCOL5.q30)	= 0v
.ic v(XARRAY_TOP.xCOL5.qb30)	= 0.7v
.ic v(XARRAY_TOP.xCOL6.q30)	= 0v
.ic v(XARRAY_TOP.xCOL6.qb30)	= 0.7v
.ic v(XARRAY_TOP.xCOL7.q30)	= 0v
.ic v(XARRAY_TOP.xCOL7.qb30)	= 0.7v
.ic v(XARRAY_TOP.xCOL8.q30)	= 0v
.ic v(XARRAY_TOP.xCOL8.qb30)	= 0.7v
.ic v(XARRAY_TOP.xCOL9.q30)	= 0v
.ic v(XARRAY_TOP.xCOL9.qb30)	= 0.7v
.ic v(XARRAY_TOP.xCOL10.q30)	= 0v
.ic v(XARRAY_TOP.xCOL10.qb30)	= 0.7v
.ic v(XARRAY_TOP.xCOL11.q30)	= 0v
.ic v(XARRAY_TOP.xCOL11.qb30)	= 0.7v
.ic v(XARRAY_TOP.xCOL12.q30)	= 0v
.ic v(XARRAY_TOP.xCOL12.qb30)	= 0.7v
.ic v(XARRAY_TOP.xCOL13.q30)	= 0v
.ic v(XARRAY_TOP.xCOL13.qb30)	= 0.7v
.ic v(XARRAY_TOP.xCOL14.q30)	= 0v
.ic v(XARRAY_TOP.xCOL14.qb30)	= 0.7v
.ic v(XARRAY_TOP.xCOL15.q30)	= 0v
.ic v(XARRAY_TOP.xCOL15.qb30)	= 0.7v
.ic v(XARRAY_TOP.xCOL16.q30)	= 0v
.ic v(XARRAY_TOP.xCOL16.qb30)	= 0.7v
.ic v(XARRAY_TOP.xCOL17.q30)	= 0v
.ic v(XARRAY_TOP.xCOL17.qb30)	= 0.7v
.ic v(XARRAY_TOP.xCOL18.q30)	= 0v
.ic v(XARRAY_TOP.xCOL18.qb30)	= 0.7v
.ic v(XARRAY_TOP.xCOL19.q30)	= 0v
.ic v(XARRAY_TOP.xCOL19.qb30)	= 0.7v
.ic v(XARRAY_TOP.xCOL20.q30)	= 0v
.ic v(XARRAY_TOP.xCOL20.qb30)	= 0.7v
.ic v(XARRAY_TOP.xCOL21.q30)	= 0v
.ic v(XARRAY_TOP.xCOL21.qb30)	= 0.7v
.ic v(XARRAY_TOP.xCOL22.q30)	= 0v
.ic v(XARRAY_TOP.xCOL22.qb30)	= 0.7v
.ic v(XARRAY_TOP.xCOL23.q30)	= 0v
.ic v(XARRAY_TOP.xCOL23.qb30)	= 0.7v
.ic v(XARRAY_TOP.xCOL24.q30)	= 0v
.ic v(XARRAY_TOP.xCOL24.qb30)	= 0.7v
.ic v(XARRAY_TOP.xCOL25.q30)	= 0v
.ic v(XARRAY_TOP.xCOL25.qb30)	= 0.7v
.ic v(XARRAY_TOP.xCOL26.q30)	= 0v
.ic v(XARRAY_TOP.xCOL26.qb30)	= 0.7v
.ic v(XARRAY_TOP.xCOL27.q30)	= 0v
.ic v(XARRAY_TOP.xCOL27.qb30)	= 0.7v
.ic v(XARRAY_TOP.xCOL28.q30)	= 0v
.ic v(XARRAY_TOP.xCOL28.qb30)	= 0.7v
.ic v(XARRAY_TOP.xCOL29.q30)	= 0v
.ic v(XARRAY_TOP.xCOL29.qb30)	= 0.7v
.ic v(XARRAY_TOP.xCOL30.q30)	= 0v
.ic v(XARRAY_TOP.xCOL30.qb30)	= 0.7v
.ic v(XARRAY_TOP.xCOL31.q30)	= 0v
.ic v(XARRAY_TOP.xCOL31.qb30)	= 0.7v
.ic v(XARRAY_TOP.xCOL0.q31)	= 0v
.ic v(XARRAY_TOP.xCOL0.qb31)	= 0.7v
.ic v(XARRAY_TOP.xCOL1.q31)	= 0v
.ic v(XARRAY_TOP.xCOL1.qb31)	= 0.7v
.ic v(XARRAY_TOP.xCOL2.q31)	= 0v
.ic v(XARRAY_TOP.xCOL2.qb31)	= 0.7v
.ic v(XARRAY_TOP.xCOL3.q31)	= 0v
.ic v(XARRAY_TOP.xCOL3.qb31)	= 0.7v
.ic v(XARRAY_TOP.xCOL4.q31)	= 0v
.ic v(XARRAY_TOP.xCOL4.qb31)	= 0.7v
.ic v(XARRAY_TOP.xCOL5.q31)	= 0v
.ic v(XARRAY_TOP.xCOL5.qb31)	= 0.7v
.ic v(XARRAY_TOP.xCOL6.q31)	= 0v
.ic v(XARRAY_TOP.xCOL6.qb31)	= 0.7v
.ic v(XARRAY_TOP.xCOL7.q31)	= 0v
.ic v(XARRAY_TOP.xCOL7.qb31)	= 0.7v
.ic v(XARRAY_TOP.xCOL8.q31)	= 0v
.ic v(XARRAY_TOP.xCOL8.qb31)	= 0.7v
.ic v(XARRAY_TOP.xCOL9.q31)	= 0v
.ic v(XARRAY_TOP.xCOL9.qb31)	= 0.7v
.ic v(XARRAY_TOP.xCOL10.q31)	= 0v
.ic v(XARRAY_TOP.xCOL10.qb31)	= 0.7v
.ic v(XARRAY_TOP.xCOL11.q31)	= 0v
.ic v(XARRAY_TOP.xCOL11.qb31)	= 0.7v
.ic v(XARRAY_TOP.xCOL12.q31)	= 0v
.ic v(XARRAY_TOP.xCOL12.qb31)	= 0.7v
.ic v(XARRAY_TOP.xCOL13.q31)	= 0v
.ic v(XARRAY_TOP.xCOL13.qb31)	= 0.7v
.ic v(XARRAY_TOP.xCOL14.q31)	= 0v
.ic v(XARRAY_TOP.xCOL14.qb31)	= 0.7v
.ic v(XARRAY_TOP.xCOL15.q31)	= 0v
.ic v(XARRAY_TOP.xCOL15.qb31)	= 0.7v
.ic v(XARRAY_TOP.xCOL16.q31)	= 0v
.ic v(XARRAY_TOP.xCOL16.qb31)	= 0.7v
.ic v(XARRAY_TOP.xCOL17.q31)	= 0v
.ic v(XARRAY_TOP.xCOL17.qb31)	= 0.7v
.ic v(XARRAY_TOP.xCOL18.q31)	= 0v
.ic v(XARRAY_TOP.xCOL18.qb31)	= 0.7v
.ic v(XARRAY_TOP.xCOL19.q31)	= 0v
.ic v(XARRAY_TOP.xCOL19.qb31)	= 0.7v
.ic v(XARRAY_TOP.xCOL20.q31)	= 0v
.ic v(XARRAY_TOP.xCOL20.qb31)	= 0.7v
.ic v(XARRAY_TOP.xCOL21.q31)	= 0v
.ic v(XARRAY_TOP.xCOL21.qb31)	= 0.7v
.ic v(XARRAY_TOP.xCOL22.q31)	= 0v
.ic v(XARRAY_TOP.xCOL22.qb31)	= 0.7v
.ic v(XARRAY_TOP.xCOL23.q31)	= 0v
.ic v(XARRAY_TOP.xCOL23.qb31)	= 0.7v
.ic v(XARRAY_TOP.xCOL24.q31)	= 0v
.ic v(XARRAY_TOP.xCOL24.qb31)	= 0.7v
.ic v(XARRAY_TOP.xCOL25.q31)	= 0v
.ic v(XARRAY_TOP.xCOL25.qb31)	= 0.7v
.ic v(XARRAY_TOP.xCOL26.q31)	= 0v
.ic v(XARRAY_TOP.xCOL26.qb31)	= 0.7v
.ic v(XARRAY_TOP.xCOL27.q31)	= 0v
.ic v(XARRAY_TOP.xCOL27.qb31)	= 0.7v
.ic v(XARRAY_TOP.xCOL28.q31)	= 0v
.ic v(XARRAY_TOP.xCOL28.qb31)	= 0.7v
.ic v(XARRAY_TOP.xCOL29.q31)	= 0v
.ic v(XARRAY_TOP.xCOL29.qb31)	= 0.7v
.ic v(XARRAY_TOP.xCOL30.q31)	= 0v
.ic v(XARRAY_TOP.xCOL30.qb31)	= 0.7v
.ic v(XARRAY_TOP.xCOL31.q31)	= 0v
.ic v(XARRAY_TOP.xCOL31.qb31)	= 0.7v
.ic v(XARRAY_TOP.xCOL0.q32)	= 0v
.ic v(XARRAY_TOP.xCOL0.qb32)	= 0.7v
.ic v(XARRAY_TOP.xCOL1.q32)	= 0v
.ic v(XARRAY_TOP.xCOL1.qb32)	= 0.7v
.ic v(XARRAY_TOP.xCOL2.q32)	= 0v
.ic v(XARRAY_TOP.xCOL2.qb32)	= 0.7v
.ic v(XARRAY_TOP.xCOL3.q32)	= 0v
.ic v(XARRAY_TOP.xCOL3.qb32)	= 0.7v
.ic v(XARRAY_TOP.xCOL4.q32)	= 0v
.ic v(XARRAY_TOP.xCOL4.qb32)	= 0.7v
.ic v(XARRAY_TOP.xCOL5.q32)	= 0v
.ic v(XARRAY_TOP.xCOL5.qb32)	= 0.7v
.ic v(XARRAY_TOP.xCOL6.q32)	= 0v
.ic v(XARRAY_TOP.xCOL6.qb32)	= 0.7v
.ic v(XARRAY_TOP.xCOL7.q32)	= 0v
.ic v(XARRAY_TOP.xCOL7.qb32)	= 0.7v
.ic v(XARRAY_TOP.xCOL8.q32)	= 0v
.ic v(XARRAY_TOP.xCOL8.qb32)	= 0.7v
.ic v(XARRAY_TOP.xCOL9.q32)	= 0v
.ic v(XARRAY_TOP.xCOL9.qb32)	= 0.7v
.ic v(XARRAY_TOP.xCOL10.q32)	= 0v
.ic v(XARRAY_TOP.xCOL10.qb32)	= 0.7v
.ic v(XARRAY_TOP.xCOL11.q32)	= 0v
.ic v(XARRAY_TOP.xCOL11.qb32)	= 0.7v
.ic v(XARRAY_TOP.xCOL12.q32)	= 0v
.ic v(XARRAY_TOP.xCOL12.qb32)	= 0.7v
.ic v(XARRAY_TOP.xCOL13.q32)	= 0v
.ic v(XARRAY_TOP.xCOL13.qb32)	= 0.7v
.ic v(XARRAY_TOP.xCOL14.q32)	= 0v
.ic v(XARRAY_TOP.xCOL14.qb32)	= 0.7v
.ic v(XARRAY_TOP.xCOL15.q32)	= 0v
.ic v(XARRAY_TOP.xCOL15.qb32)	= 0.7v
.ic v(XARRAY_TOP.xCOL16.q32)	= 0v
.ic v(XARRAY_TOP.xCOL16.qb32)	= 0.7v
.ic v(XARRAY_TOP.xCOL17.q32)	= 0v
.ic v(XARRAY_TOP.xCOL17.qb32)	= 0.7v
.ic v(XARRAY_TOP.xCOL18.q32)	= 0v
.ic v(XARRAY_TOP.xCOL18.qb32)	= 0.7v
.ic v(XARRAY_TOP.xCOL19.q32)	= 0v
.ic v(XARRAY_TOP.xCOL19.qb32)	= 0.7v
.ic v(XARRAY_TOP.xCOL20.q32)	= 0v
.ic v(XARRAY_TOP.xCOL20.qb32)	= 0.7v
.ic v(XARRAY_TOP.xCOL21.q32)	= 0v
.ic v(XARRAY_TOP.xCOL21.qb32)	= 0.7v
.ic v(XARRAY_TOP.xCOL22.q32)	= 0v
.ic v(XARRAY_TOP.xCOL22.qb32)	= 0.7v
.ic v(XARRAY_TOP.xCOL23.q32)	= 0v
.ic v(XARRAY_TOP.xCOL23.qb32)	= 0.7v
.ic v(XARRAY_TOP.xCOL24.q32)	= 0v
.ic v(XARRAY_TOP.xCOL24.qb32)	= 0.7v
.ic v(XARRAY_TOP.xCOL25.q32)	= 0v
.ic v(XARRAY_TOP.xCOL25.qb32)	= 0.7v
.ic v(XARRAY_TOP.xCOL26.q32)	= 0v
.ic v(XARRAY_TOP.xCOL26.qb32)	= 0.7v
.ic v(XARRAY_TOP.xCOL27.q32)	= 0v
.ic v(XARRAY_TOP.xCOL27.qb32)	= 0.7v
.ic v(XARRAY_TOP.xCOL28.q32)	= 0v
.ic v(XARRAY_TOP.xCOL28.qb32)	= 0.7v
.ic v(XARRAY_TOP.xCOL29.q32)	= 0v
.ic v(XARRAY_TOP.xCOL29.qb32)	= 0.7v
.ic v(XARRAY_TOP.xCOL30.q32)	= 0v
.ic v(XARRAY_TOP.xCOL30.qb32)	= 0.7v
.ic v(XARRAY_TOP.xCOL31.q32)	= 0v
.ic v(XARRAY_TOP.xCOL31.qb32)	= 0.7v
.ic v(XARRAY_TOP.xCOL0.q33)	= 0v
.ic v(XARRAY_TOP.xCOL0.qb33)	= 0.7v
.ic v(XARRAY_TOP.xCOL1.q33)	= 0v
.ic v(XARRAY_TOP.xCOL1.qb33)	= 0.7v
.ic v(XARRAY_TOP.xCOL2.q33)	= 0v
.ic v(XARRAY_TOP.xCOL2.qb33)	= 0.7v
.ic v(XARRAY_TOP.xCOL3.q33)	= 0v
.ic v(XARRAY_TOP.xCOL3.qb33)	= 0.7v
.ic v(XARRAY_TOP.xCOL4.q33)	= 0v
.ic v(XARRAY_TOP.xCOL4.qb33)	= 0.7v
.ic v(XARRAY_TOP.xCOL5.q33)	= 0v
.ic v(XARRAY_TOP.xCOL5.qb33)	= 0.7v
.ic v(XARRAY_TOP.xCOL6.q33)	= 0v
.ic v(XARRAY_TOP.xCOL6.qb33)	= 0.7v
.ic v(XARRAY_TOP.xCOL7.q33)	= 0v
.ic v(XARRAY_TOP.xCOL7.qb33)	= 0.7v
.ic v(XARRAY_TOP.xCOL8.q33)	= 0v
.ic v(XARRAY_TOP.xCOL8.qb33)	= 0.7v
.ic v(XARRAY_TOP.xCOL9.q33)	= 0v
.ic v(XARRAY_TOP.xCOL9.qb33)	= 0.7v
.ic v(XARRAY_TOP.xCOL10.q33)	= 0v
.ic v(XARRAY_TOP.xCOL10.qb33)	= 0.7v
.ic v(XARRAY_TOP.xCOL11.q33)	= 0v
.ic v(XARRAY_TOP.xCOL11.qb33)	= 0.7v
.ic v(XARRAY_TOP.xCOL12.q33)	= 0v
.ic v(XARRAY_TOP.xCOL12.qb33)	= 0.7v
.ic v(XARRAY_TOP.xCOL13.q33)	= 0v
.ic v(XARRAY_TOP.xCOL13.qb33)	= 0.7v
.ic v(XARRAY_TOP.xCOL14.q33)	= 0v
.ic v(XARRAY_TOP.xCOL14.qb33)	= 0.7v
.ic v(XARRAY_TOP.xCOL15.q33)	= 0v
.ic v(XARRAY_TOP.xCOL15.qb33)	= 0.7v
.ic v(XARRAY_TOP.xCOL16.q33)	= 0v
.ic v(XARRAY_TOP.xCOL16.qb33)	= 0.7v
.ic v(XARRAY_TOP.xCOL17.q33)	= 0v
.ic v(XARRAY_TOP.xCOL17.qb33)	= 0.7v
.ic v(XARRAY_TOP.xCOL18.q33)	= 0v
.ic v(XARRAY_TOP.xCOL18.qb33)	= 0.7v
.ic v(XARRAY_TOP.xCOL19.q33)	= 0v
.ic v(XARRAY_TOP.xCOL19.qb33)	= 0.7v
.ic v(XARRAY_TOP.xCOL20.q33)	= 0v
.ic v(XARRAY_TOP.xCOL20.qb33)	= 0.7v
.ic v(XARRAY_TOP.xCOL21.q33)	= 0v
.ic v(XARRAY_TOP.xCOL21.qb33)	= 0.7v
.ic v(XARRAY_TOP.xCOL22.q33)	= 0v
.ic v(XARRAY_TOP.xCOL22.qb33)	= 0.7v
.ic v(XARRAY_TOP.xCOL23.q33)	= 0v
.ic v(XARRAY_TOP.xCOL23.qb33)	= 0.7v
.ic v(XARRAY_TOP.xCOL24.q33)	= 0v
.ic v(XARRAY_TOP.xCOL24.qb33)	= 0.7v
.ic v(XARRAY_TOP.xCOL25.q33)	= 0v
.ic v(XARRAY_TOP.xCOL25.qb33)	= 0.7v
.ic v(XARRAY_TOP.xCOL26.q33)	= 0v
.ic v(XARRAY_TOP.xCOL26.qb33)	= 0.7v
.ic v(XARRAY_TOP.xCOL27.q33)	= 0v
.ic v(XARRAY_TOP.xCOL27.qb33)	= 0.7v
.ic v(XARRAY_TOP.xCOL28.q33)	= 0v
.ic v(XARRAY_TOP.xCOL28.qb33)	= 0.7v
.ic v(XARRAY_TOP.xCOL29.q33)	= 0v
.ic v(XARRAY_TOP.xCOL29.qb33)	= 0.7v
.ic v(XARRAY_TOP.xCOL30.q33)	= 0v
.ic v(XARRAY_TOP.xCOL30.qb33)	= 0.7v
.ic v(XARRAY_TOP.xCOL31.q33)	= 0v
.ic v(XARRAY_TOP.xCOL31.qb33)	= 0.7v
.ic v(XARRAY_TOP.xCOL0.q34)	= 0v
.ic v(XARRAY_TOP.xCOL0.qb34)	= 0.7v
.ic v(XARRAY_TOP.xCOL1.q34)	= 0v
.ic v(XARRAY_TOP.xCOL1.qb34)	= 0.7v
.ic v(XARRAY_TOP.xCOL2.q34)	= 0v
.ic v(XARRAY_TOP.xCOL2.qb34)	= 0.7v
.ic v(XARRAY_TOP.xCOL3.q34)	= 0v
.ic v(XARRAY_TOP.xCOL3.qb34)	= 0.7v
.ic v(XARRAY_TOP.xCOL4.q34)	= 0v
.ic v(XARRAY_TOP.xCOL4.qb34)	= 0.7v
.ic v(XARRAY_TOP.xCOL5.q34)	= 0v
.ic v(XARRAY_TOP.xCOL5.qb34)	= 0.7v
.ic v(XARRAY_TOP.xCOL6.q34)	= 0v
.ic v(XARRAY_TOP.xCOL6.qb34)	= 0.7v
.ic v(XARRAY_TOP.xCOL7.q34)	= 0v
.ic v(XARRAY_TOP.xCOL7.qb34)	= 0.7v
.ic v(XARRAY_TOP.xCOL8.q34)	= 0v
.ic v(XARRAY_TOP.xCOL8.qb34)	= 0.7v
.ic v(XARRAY_TOP.xCOL9.q34)	= 0v
.ic v(XARRAY_TOP.xCOL9.qb34)	= 0.7v
.ic v(XARRAY_TOP.xCOL10.q34)	= 0v
.ic v(XARRAY_TOP.xCOL10.qb34)	= 0.7v
.ic v(XARRAY_TOP.xCOL11.q34)	= 0v
.ic v(XARRAY_TOP.xCOL11.qb34)	= 0.7v
.ic v(XARRAY_TOP.xCOL12.q34)	= 0v
.ic v(XARRAY_TOP.xCOL12.qb34)	= 0.7v
.ic v(XARRAY_TOP.xCOL13.q34)	= 0v
.ic v(XARRAY_TOP.xCOL13.qb34)	= 0.7v
.ic v(XARRAY_TOP.xCOL14.q34)	= 0v
.ic v(XARRAY_TOP.xCOL14.qb34)	= 0.7v
.ic v(XARRAY_TOP.xCOL15.q34)	= 0v
.ic v(XARRAY_TOP.xCOL15.qb34)	= 0.7v
.ic v(XARRAY_TOP.xCOL16.q34)	= 0v
.ic v(XARRAY_TOP.xCOL16.qb34)	= 0.7v
.ic v(XARRAY_TOP.xCOL17.q34)	= 0v
.ic v(XARRAY_TOP.xCOL17.qb34)	= 0.7v
.ic v(XARRAY_TOP.xCOL18.q34)	= 0v
.ic v(XARRAY_TOP.xCOL18.qb34)	= 0.7v
.ic v(XARRAY_TOP.xCOL19.q34)	= 0v
.ic v(XARRAY_TOP.xCOL19.qb34)	= 0.7v
.ic v(XARRAY_TOP.xCOL20.q34)	= 0v
.ic v(XARRAY_TOP.xCOL20.qb34)	= 0.7v
.ic v(XARRAY_TOP.xCOL21.q34)	= 0v
.ic v(XARRAY_TOP.xCOL21.qb34)	= 0.7v
.ic v(XARRAY_TOP.xCOL22.q34)	= 0v
.ic v(XARRAY_TOP.xCOL22.qb34)	= 0.7v
.ic v(XARRAY_TOP.xCOL23.q34)	= 0v
.ic v(XARRAY_TOP.xCOL23.qb34)	= 0.7v
.ic v(XARRAY_TOP.xCOL24.q34)	= 0v
.ic v(XARRAY_TOP.xCOL24.qb34)	= 0.7v
.ic v(XARRAY_TOP.xCOL25.q34)	= 0v
.ic v(XARRAY_TOP.xCOL25.qb34)	= 0.7v
.ic v(XARRAY_TOP.xCOL26.q34)	= 0v
.ic v(XARRAY_TOP.xCOL26.qb34)	= 0.7v
.ic v(XARRAY_TOP.xCOL27.q34)	= 0v
.ic v(XARRAY_TOP.xCOL27.qb34)	= 0.7v
.ic v(XARRAY_TOP.xCOL28.q34)	= 0v
.ic v(XARRAY_TOP.xCOL28.qb34)	= 0.7v
.ic v(XARRAY_TOP.xCOL29.q34)	= 0v
.ic v(XARRAY_TOP.xCOL29.qb34)	= 0.7v
.ic v(XARRAY_TOP.xCOL30.q34)	= 0v
.ic v(XARRAY_TOP.xCOL30.qb34)	= 0.7v
.ic v(XARRAY_TOP.xCOL31.q34)	= 0v
.ic v(XARRAY_TOP.xCOL31.qb34)	= 0.7v
.ic v(XARRAY_TOP.xCOL0.q35)	= 0v
.ic v(XARRAY_TOP.xCOL0.qb35)	= 0.7v
.ic v(XARRAY_TOP.xCOL1.q35)	= 0v
.ic v(XARRAY_TOP.xCOL1.qb35)	= 0.7v
.ic v(XARRAY_TOP.xCOL2.q35)	= 0v
.ic v(XARRAY_TOP.xCOL2.qb35)	= 0.7v
.ic v(XARRAY_TOP.xCOL3.q35)	= 0v
.ic v(XARRAY_TOP.xCOL3.qb35)	= 0.7v
.ic v(XARRAY_TOP.xCOL4.q35)	= 0v
.ic v(XARRAY_TOP.xCOL4.qb35)	= 0.7v
.ic v(XARRAY_TOP.xCOL5.q35)	= 0v
.ic v(XARRAY_TOP.xCOL5.qb35)	= 0.7v
.ic v(XARRAY_TOP.xCOL6.q35)	= 0v
.ic v(XARRAY_TOP.xCOL6.qb35)	= 0.7v
.ic v(XARRAY_TOP.xCOL7.q35)	= 0v
.ic v(XARRAY_TOP.xCOL7.qb35)	= 0.7v
.ic v(XARRAY_TOP.xCOL8.q35)	= 0v
.ic v(XARRAY_TOP.xCOL8.qb35)	= 0.7v
.ic v(XARRAY_TOP.xCOL9.q35)	= 0v
.ic v(XARRAY_TOP.xCOL9.qb35)	= 0.7v
.ic v(XARRAY_TOP.xCOL10.q35)	= 0v
.ic v(XARRAY_TOP.xCOL10.qb35)	= 0.7v
.ic v(XARRAY_TOP.xCOL11.q35)	= 0v
.ic v(XARRAY_TOP.xCOL11.qb35)	= 0.7v
.ic v(XARRAY_TOP.xCOL12.q35)	= 0v
.ic v(XARRAY_TOP.xCOL12.qb35)	= 0.7v
.ic v(XARRAY_TOP.xCOL13.q35)	= 0v
.ic v(XARRAY_TOP.xCOL13.qb35)	= 0.7v
.ic v(XARRAY_TOP.xCOL14.q35)	= 0v
.ic v(XARRAY_TOP.xCOL14.qb35)	= 0.7v
.ic v(XARRAY_TOP.xCOL15.q35)	= 0v
.ic v(XARRAY_TOP.xCOL15.qb35)	= 0.7v
.ic v(XARRAY_TOP.xCOL16.q35)	= 0v
.ic v(XARRAY_TOP.xCOL16.qb35)	= 0.7v
.ic v(XARRAY_TOP.xCOL17.q35)	= 0v
.ic v(XARRAY_TOP.xCOL17.qb35)	= 0.7v
.ic v(XARRAY_TOP.xCOL18.q35)	= 0v
.ic v(XARRAY_TOP.xCOL18.qb35)	= 0.7v
.ic v(XARRAY_TOP.xCOL19.q35)	= 0v
.ic v(XARRAY_TOP.xCOL19.qb35)	= 0.7v
.ic v(XARRAY_TOP.xCOL20.q35)	= 0v
.ic v(XARRAY_TOP.xCOL20.qb35)	= 0.7v
.ic v(XARRAY_TOP.xCOL21.q35)	= 0v
.ic v(XARRAY_TOP.xCOL21.qb35)	= 0.7v
.ic v(XARRAY_TOP.xCOL22.q35)	= 0v
.ic v(XARRAY_TOP.xCOL22.qb35)	= 0.7v
.ic v(XARRAY_TOP.xCOL23.q35)	= 0v
.ic v(XARRAY_TOP.xCOL23.qb35)	= 0.7v
.ic v(XARRAY_TOP.xCOL24.q35)	= 0v
.ic v(XARRAY_TOP.xCOL24.qb35)	= 0.7v
.ic v(XARRAY_TOP.xCOL25.q35)	= 0v
.ic v(XARRAY_TOP.xCOL25.qb35)	= 0.7v
.ic v(XARRAY_TOP.xCOL26.q35)	= 0v
.ic v(XARRAY_TOP.xCOL26.qb35)	= 0.7v
.ic v(XARRAY_TOP.xCOL27.q35)	= 0v
.ic v(XARRAY_TOP.xCOL27.qb35)	= 0.7v
.ic v(XARRAY_TOP.xCOL28.q35)	= 0v
.ic v(XARRAY_TOP.xCOL28.qb35)	= 0.7v
.ic v(XARRAY_TOP.xCOL29.q35)	= 0v
.ic v(XARRAY_TOP.xCOL29.qb35)	= 0.7v
.ic v(XARRAY_TOP.xCOL30.q35)	= 0v
.ic v(XARRAY_TOP.xCOL30.qb35)	= 0.7v
.ic v(XARRAY_TOP.xCOL31.q35)	= 0v
.ic v(XARRAY_TOP.xCOL31.qb35)	= 0.7v
.ic v(XARRAY_TOP.xCOL0.q36)	= 0v
.ic v(XARRAY_TOP.xCOL0.qb36)	= 0.7v
.ic v(XARRAY_TOP.xCOL1.q36)	= 0v
.ic v(XARRAY_TOP.xCOL1.qb36)	= 0.7v
.ic v(XARRAY_TOP.xCOL2.q36)	= 0v
.ic v(XARRAY_TOP.xCOL2.qb36)	= 0.7v
.ic v(XARRAY_TOP.xCOL3.q36)	= 0v
.ic v(XARRAY_TOP.xCOL3.qb36)	= 0.7v
.ic v(XARRAY_TOP.xCOL4.q36)	= 0v
.ic v(XARRAY_TOP.xCOL4.qb36)	= 0.7v
.ic v(XARRAY_TOP.xCOL5.q36)	= 0v
.ic v(XARRAY_TOP.xCOL5.qb36)	= 0.7v
.ic v(XARRAY_TOP.xCOL6.q36)	= 0v
.ic v(XARRAY_TOP.xCOL6.qb36)	= 0.7v
.ic v(XARRAY_TOP.xCOL7.q36)	= 0v
.ic v(XARRAY_TOP.xCOL7.qb36)	= 0.7v
.ic v(XARRAY_TOP.xCOL8.q36)	= 0v
.ic v(XARRAY_TOP.xCOL8.qb36)	= 0.7v
.ic v(XARRAY_TOP.xCOL9.q36)	= 0v
.ic v(XARRAY_TOP.xCOL9.qb36)	= 0.7v
.ic v(XARRAY_TOP.xCOL10.q36)	= 0v
.ic v(XARRAY_TOP.xCOL10.qb36)	= 0.7v
.ic v(XARRAY_TOP.xCOL11.q36)	= 0v
.ic v(XARRAY_TOP.xCOL11.qb36)	= 0.7v
.ic v(XARRAY_TOP.xCOL12.q36)	= 0v
.ic v(XARRAY_TOP.xCOL12.qb36)	= 0.7v
.ic v(XARRAY_TOP.xCOL13.q36)	= 0v
.ic v(XARRAY_TOP.xCOL13.qb36)	= 0.7v
.ic v(XARRAY_TOP.xCOL14.q36)	= 0v
.ic v(XARRAY_TOP.xCOL14.qb36)	= 0.7v
.ic v(XARRAY_TOP.xCOL15.q36)	= 0v
.ic v(XARRAY_TOP.xCOL15.qb36)	= 0.7v
.ic v(XARRAY_TOP.xCOL16.q36)	= 0v
.ic v(XARRAY_TOP.xCOL16.qb36)	= 0.7v
.ic v(XARRAY_TOP.xCOL17.q36)	= 0v
.ic v(XARRAY_TOP.xCOL17.qb36)	= 0.7v
.ic v(XARRAY_TOP.xCOL18.q36)	= 0v
.ic v(XARRAY_TOP.xCOL18.qb36)	= 0.7v
.ic v(XARRAY_TOP.xCOL19.q36)	= 0v
.ic v(XARRAY_TOP.xCOL19.qb36)	= 0.7v
.ic v(XARRAY_TOP.xCOL20.q36)	= 0v
.ic v(XARRAY_TOP.xCOL20.qb36)	= 0.7v
.ic v(XARRAY_TOP.xCOL21.q36)	= 0v
.ic v(XARRAY_TOP.xCOL21.qb36)	= 0.7v
.ic v(XARRAY_TOP.xCOL22.q36)	= 0v
.ic v(XARRAY_TOP.xCOL22.qb36)	= 0.7v
.ic v(XARRAY_TOP.xCOL23.q36)	= 0v
.ic v(XARRAY_TOP.xCOL23.qb36)	= 0.7v
.ic v(XARRAY_TOP.xCOL24.q36)	= 0v
.ic v(XARRAY_TOP.xCOL24.qb36)	= 0.7v
.ic v(XARRAY_TOP.xCOL25.q36)	= 0v
.ic v(XARRAY_TOP.xCOL25.qb36)	= 0.7v
.ic v(XARRAY_TOP.xCOL26.q36)	= 0v
.ic v(XARRAY_TOP.xCOL26.qb36)	= 0.7v
.ic v(XARRAY_TOP.xCOL27.q36)	= 0v
.ic v(XARRAY_TOP.xCOL27.qb36)	= 0.7v
.ic v(XARRAY_TOP.xCOL28.q36)	= 0v
.ic v(XARRAY_TOP.xCOL28.qb36)	= 0.7v
.ic v(XARRAY_TOP.xCOL29.q36)	= 0v
.ic v(XARRAY_TOP.xCOL29.qb36)	= 0.7v
.ic v(XARRAY_TOP.xCOL30.q36)	= 0v
.ic v(XARRAY_TOP.xCOL30.qb36)	= 0.7v
.ic v(XARRAY_TOP.xCOL31.q36)	= 0v
.ic v(XARRAY_TOP.xCOL31.qb36)	= 0.7v
.ic v(XARRAY_TOP.xCOL0.q37)	= 0v
.ic v(XARRAY_TOP.xCOL0.qb37)	= 0.7v
.ic v(XARRAY_TOP.xCOL1.q37)	= 0v
.ic v(XARRAY_TOP.xCOL1.qb37)	= 0.7v
.ic v(XARRAY_TOP.xCOL2.q37)	= 0v
.ic v(XARRAY_TOP.xCOL2.qb37)	= 0.7v
.ic v(XARRAY_TOP.xCOL3.q37)	= 0v
.ic v(XARRAY_TOP.xCOL3.qb37)	= 0.7v
.ic v(XARRAY_TOP.xCOL4.q37)	= 0v
.ic v(XARRAY_TOP.xCOL4.qb37)	= 0.7v
.ic v(XARRAY_TOP.xCOL5.q37)	= 0v
.ic v(XARRAY_TOP.xCOL5.qb37)	= 0.7v
.ic v(XARRAY_TOP.xCOL6.q37)	= 0v
.ic v(XARRAY_TOP.xCOL6.qb37)	= 0.7v
.ic v(XARRAY_TOP.xCOL7.q37)	= 0v
.ic v(XARRAY_TOP.xCOL7.qb37)	= 0.7v
.ic v(XARRAY_TOP.xCOL8.q37)	= 0v
.ic v(XARRAY_TOP.xCOL8.qb37)	= 0.7v
.ic v(XARRAY_TOP.xCOL9.q37)	= 0v
.ic v(XARRAY_TOP.xCOL9.qb37)	= 0.7v
.ic v(XARRAY_TOP.xCOL10.q37)	= 0v
.ic v(XARRAY_TOP.xCOL10.qb37)	= 0.7v
.ic v(XARRAY_TOP.xCOL11.q37)	= 0v
.ic v(XARRAY_TOP.xCOL11.qb37)	= 0.7v
.ic v(XARRAY_TOP.xCOL12.q37)	= 0v
.ic v(XARRAY_TOP.xCOL12.qb37)	= 0.7v
.ic v(XARRAY_TOP.xCOL13.q37)	= 0v
.ic v(XARRAY_TOP.xCOL13.qb37)	= 0.7v
.ic v(XARRAY_TOP.xCOL14.q37)	= 0v
.ic v(XARRAY_TOP.xCOL14.qb37)	= 0.7v
.ic v(XARRAY_TOP.xCOL15.q37)	= 0v
.ic v(XARRAY_TOP.xCOL15.qb37)	= 0.7v
.ic v(XARRAY_TOP.xCOL16.q37)	= 0v
.ic v(XARRAY_TOP.xCOL16.qb37)	= 0.7v
.ic v(XARRAY_TOP.xCOL17.q37)	= 0v
.ic v(XARRAY_TOP.xCOL17.qb37)	= 0.7v
.ic v(XARRAY_TOP.xCOL18.q37)	= 0v
.ic v(XARRAY_TOP.xCOL18.qb37)	= 0.7v
.ic v(XARRAY_TOP.xCOL19.q37)	= 0v
.ic v(XARRAY_TOP.xCOL19.qb37)	= 0.7v
.ic v(XARRAY_TOP.xCOL20.q37)	= 0v
.ic v(XARRAY_TOP.xCOL20.qb37)	= 0.7v
.ic v(XARRAY_TOP.xCOL21.q37)	= 0v
.ic v(XARRAY_TOP.xCOL21.qb37)	= 0.7v
.ic v(XARRAY_TOP.xCOL22.q37)	= 0v
.ic v(XARRAY_TOP.xCOL22.qb37)	= 0.7v
.ic v(XARRAY_TOP.xCOL23.q37)	= 0v
.ic v(XARRAY_TOP.xCOL23.qb37)	= 0.7v
.ic v(XARRAY_TOP.xCOL24.q37)	= 0v
.ic v(XARRAY_TOP.xCOL24.qb37)	= 0.7v
.ic v(XARRAY_TOP.xCOL25.q37)	= 0v
.ic v(XARRAY_TOP.xCOL25.qb37)	= 0.7v
.ic v(XARRAY_TOP.xCOL26.q37)	= 0v
.ic v(XARRAY_TOP.xCOL26.qb37)	= 0.7v
.ic v(XARRAY_TOP.xCOL27.q37)	= 0v
.ic v(XARRAY_TOP.xCOL27.qb37)	= 0.7v
.ic v(XARRAY_TOP.xCOL28.q37)	= 0v
.ic v(XARRAY_TOP.xCOL28.qb37)	= 0.7v
.ic v(XARRAY_TOP.xCOL29.q37)	= 0v
.ic v(XARRAY_TOP.xCOL29.qb37)	= 0.7v
.ic v(XARRAY_TOP.xCOL30.q37)	= 0v
.ic v(XARRAY_TOP.xCOL30.qb37)	= 0.7v
.ic v(XARRAY_TOP.xCOL31.q37)	= 0v
.ic v(XARRAY_TOP.xCOL31.qb37)	= 0.7v
.ic v(XARRAY_TOP.xCOL0.q38)	= 0v
.ic v(XARRAY_TOP.xCOL0.qb38)	= 0.7v
.ic v(XARRAY_TOP.xCOL1.q38)	= 0v
.ic v(XARRAY_TOP.xCOL1.qb38)	= 0.7v
.ic v(XARRAY_TOP.xCOL2.q38)	= 0v
.ic v(XARRAY_TOP.xCOL2.qb38)	= 0.7v
.ic v(XARRAY_TOP.xCOL3.q38)	= 0v
.ic v(XARRAY_TOP.xCOL3.qb38)	= 0.7v
.ic v(XARRAY_TOP.xCOL4.q38)	= 0v
.ic v(XARRAY_TOP.xCOL4.qb38)	= 0.7v
.ic v(XARRAY_TOP.xCOL5.q38)	= 0v
.ic v(XARRAY_TOP.xCOL5.qb38)	= 0.7v
.ic v(XARRAY_TOP.xCOL6.q38)	= 0v
.ic v(XARRAY_TOP.xCOL6.qb38)	= 0.7v
.ic v(XARRAY_TOP.xCOL7.q38)	= 0v
.ic v(XARRAY_TOP.xCOL7.qb38)	= 0.7v
.ic v(XARRAY_TOP.xCOL8.q38)	= 0v
.ic v(XARRAY_TOP.xCOL8.qb38)	= 0.7v
.ic v(XARRAY_TOP.xCOL9.q38)	= 0v
.ic v(XARRAY_TOP.xCOL9.qb38)	= 0.7v
.ic v(XARRAY_TOP.xCOL10.q38)	= 0v
.ic v(XARRAY_TOP.xCOL10.qb38)	= 0.7v
.ic v(XARRAY_TOP.xCOL11.q38)	= 0v
.ic v(XARRAY_TOP.xCOL11.qb38)	= 0.7v
.ic v(XARRAY_TOP.xCOL12.q38)	= 0v
.ic v(XARRAY_TOP.xCOL12.qb38)	= 0.7v
.ic v(XARRAY_TOP.xCOL13.q38)	= 0v
.ic v(XARRAY_TOP.xCOL13.qb38)	= 0.7v
.ic v(XARRAY_TOP.xCOL14.q38)	= 0v
.ic v(XARRAY_TOP.xCOL14.qb38)	= 0.7v
.ic v(XARRAY_TOP.xCOL15.q38)	= 0v
.ic v(XARRAY_TOP.xCOL15.qb38)	= 0.7v
.ic v(XARRAY_TOP.xCOL16.q38)	= 0v
.ic v(XARRAY_TOP.xCOL16.qb38)	= 0.7v
.ic v(XARRAY_TOP.xCOL17.q38)	= 0v
.ic v(XARRAY_TOP.xCOL17.qb38)	= 0.7v
.ic v(XARRAY_TOP.xCOL18.q38)	= 0v
.ic v(XARRAY_TOP.xCOL18.qb38)	= 0.7v
.ic v(XARRAY_TOP.xCOL19.q38)	= 0v
.ic v(XARRAY_TOP.xCOL19.qb38)	= 0.7v
.ic v(XARRAY_TOP.xCOL20.q38)	= 0v
.ic v(XARRAY_TOP.xCOL20.qb38)	= 0.7v
.ic v(XARRAY_TOP.xCOL21.q38)	= 0v
.ic v(XARRAY_TOP.xCOL21.qb38)	= 0.7v
.ic v(XARRAY_TOP.xCOL22.q38)	= 0v
.ic v(XARRAY_TOP.xCOL22.qb38)	= 0.7v
.ic v(XARRAY_TOP.xCOL23.q38)	= 0v
.ic v(XARRAY_TOP.xCOL23.qb38)	= 0.7v
.ic v(XARRAY_TOP.xCOL24.q38)	= 0v
.ic v(XARRAY_TOP.xCOL24.qb38)	= 0.7v
.ic v(XARRAY_TOP.xCOL25.q38)	= 0v
.ic v(XARRAY_TOP.xCOL25.qb38)	= 0.7v
.ic v(XARRAY_TOP.xCOL26.q38)	= 0v
.ic v(XARRAY_TOP.xCOL26.qb38)	= 0.7v
.ic v(XARRAY_TOP.xCOL27.q38)	= 0v
.ic v(XARRAY_TOP.xCOL27.qb38)	= 0.7v
.ic v(XARRAY_TOP.xCOL28.q38)	= 0v
.ic v(XARRAY_TOP.xCOL28.qb38)	= 0.7v
.ic v(XARRAY_TOP.xCOL29.q38)	= 0v
.ic v(XARRAY_TOP.xCOL29.qb38)	= 0.7v
.ic v(XARRAY_TOP.xCOL30.q38)	= 0v
.ic v(XARRAY_TOP.xCOL30.qb38)	= 0.7v
.ic v(XARRAY_TOP.xCOL31.q38)	= 0v
.ic v(XARRAY_TOP.xCOL31.qb38)	= 0.7v
.ic v(XARRAY_TOP.xCOL0.q39)	= 0v
.ic v(XARRAY_TOP.xCOL0.qb39)	= 0.7v
.ic v(XARRAY_TOP.xCOL1.q39)	= 0v
.ic v(XARRAY_TOP.xCOL1.qb39)	= 0.7v
.ic v(XARRAY_TOP.xCOL2.q39)	= 0v
.ic v(XARRAY_TOP.xCOL2.qb39)	= 0.7v
.ic v(XARRAY_TOP.xCOL3.q39)	= 0v
.ic v(XARRAY_TOP.xCOL3.qb39)	= 0.7v
.ic v(XARRAY_TOP.xCOL4.q39)	= 0v
.ic v(XARRAY_TOP.xCOL4.qb39)	= 0.7v
.ic v(XARRAY_TOP.xCOL5.q39)	= 0v
.ic v(XARRAY_TOP.xCOL5.qb39)	= 0.7v
.ic v(XARRAY_TOP.xCOL6.q39)	= 0v
.ic v(XARRAY_TOP.xCOL6.qb39)	= 0.7v
.ic v(XARRAY_TOP.xCOL7.q39)	= 0v
.ic v(XARRAY_TOP.xCOL7.qb39)	= 0.7v
.ic v(XARRAY_TOP.xCOL8.q39)	= 0v
.ic v(XARRAY_TOP.xCOL8.qb39)	= 0.7v
.ic v(XARRAY_TOP.xCOL9.q39)	= 0v
.ic v(XARRAY_TOP.xCOL9.qb39)	= 0.7v
.ic v(XARRAY_TOP.xCOL10.q39)	= 0v
.ic v(XARRAY_TOP.xCOL10.qb39)	= 0.7v
.ic v(XARRAY_TOP.xCOL11.q39)	= 0v
.ic v(XARRAY_TOP.xCOL11.qb39)	= 0.7v
.ic v(XARRAY_TOP.xCOL12.q39)	= 0v
.ic v(XARRAY_TOP.xCOL12.qb39)	= 0.7v
.ic v(XARRAY_TOP.xCOL13.q39)	= 0v
.ic v(XARRAY_TOP.xCOL13.qb39)	= 0.7v
.ic v(XARRAY_TOP.xCOL14.q39)	= 0v
.ic v(XARRAY_TOP.xCOL14.qb39)	= 0.7v
.ic v(XARRAY_TOP.xCOL15.q39)	= 0v
.ic v(XARRAY_TOP.xCOL15.qb39)	= 0.7v
.ic v(XARRAY_TOP.xCOL16.q39)	= 0v
.ic v(XARRAY_TOP.xCOL16.qb39)	= 0.7v
.ic v(XARRAY_TOP.xCOL17.q39)	= 0v
.ic v(XARRAY_TOP.xCOL17.qb39)	= 0.7v
.ic v(XARRAY_TOP.xCOL18.q39)	= 0v
.ic v(XARRAY_TOP.xCOL18.qb39)	= 0.7v
.ic v(XARRAY_TOP.xCOL19.q39)	= 0v
.ic v(XARRAY_TOP.xCOL19.qb39)	= 0.7v
.ic v(XARRAY_TOP.xCOL20.q39)	= 0v
.ic v(XARRAY_TOP.xCOL20.qb39)	= 0.7v
.ic v(XARRAY_TOP.xCOL21.q39)	= 0v
.ic v(XARRAY_TOP.xCOL21.qb39)	= 0.7v
.ic v(XARRAY_TOP.xCOL22.q39)	= 0v
.ic v(XARRAY_TOP.xCOL22.qb39)	= 0.7v
.ic v(XARRAY_TOP.xCOL23.q39)	= 0v
.ic v(XARRAY_TOP.xCOL23.qb39)	= 0.7v
.ic v(XARRAY_TOP.xCOL24.q39)	= 0v
.ic v(XARRAY_TOP.xCOL24.qb39)	= 0.7v
.ic v(XARRAY_TOP.xCOL25.q39)	= 0v
.ic v(XARRAY_TOP.xCOL25.qb39)	= 0.7v
.ic v(XARRAY_TOP.xCOL26.q39)	= 0v
.ic v(XARRAY_TOP.xCOL26.qb39)	= 0.7v
.ic v(XARRAY_TOP.xCOL27.q39)	= 0v
.ic v(XARRAY_TOP.xCOL27.qb39)	= 0.7v
.ic v(XARRAY_TOP.xCOL28.q39)	= 0v
.ic v(XARRAY_TOP.xCOL28.qb39)	= 0.7v
.ic v(XARRAY_TOP.xCOL29.q39)	= 0v
.ic v(XARRAY_TOP.xCOL29.qb39)	= 0.7v
.ic v(XARRAY_TOP.xCOL30.q39)	= 0v
.ic v(XARRAY_TOP.xCOL30.qb39)	= 0.7v
.ic v(XARRAY_TOP.xCOL31.q39)	= 0v
.ic v(XARRAY_TOP.xCOL31.qb39)	= 0.7v
.ic v(XARRAY_TOP.xCOL0.q40)	= 0v
.ic v(XARRAY_TOP.xCOL0.qb40)	= 0.7v
.ic v(XARRAY_TOP.xCOL1.q40)	= 0v
.ic v(XARRAY_TOP.xCOL1.qb40)	= 0.7v
.ic v(XARRAY_TOP.xCOL2.q40)	= 0v
.ic v(XARRAY_TOP.xCOL2.qb40)	= 0.7v
.ic v(XARRAY_TOP.xCOL3.q40)	= 0v
.ic v(XARRAY_TOP.xCOL3.qb40)	= 0.7v
.ic v(XARRAY_TOP.xCOL4.q40)	= 0v
.ic v(XARRAY_TOP.xCOL4.qb40)	= 0.7v
.ic v(XARRAY_TOP.xCOL5.q40)	= 0v
.ic v(XARRAY_TOP.xCOL5.qb40)	= 0.7v
.ic v(XARRAY_TOP.xCOL6.q40)	= 0v
.ic v(XARRAY_TOP.xCOL6.qb40)	= 0.7v
.ic v(XARRAY_TOP.xCOL7.q40)	= 0v
.ic v(XARRAY_TOP.xCOL7.qb40)	= 0.7v
.ic v(XARRAY_TOP.xCOL8.q40)	= 0v
.ic v(XARRAY_TOP.xCOL8.qb40)	= 0.7v
.ic v(XARRAY_TOP.xCOL9.q40)	= 0v
.ic v(XARRAY_TOP.xCOL9.qb40)	= 0.7v
.ic v(XARRAY_TOP.xCOL10.q40)	= 0v
.ic v(XARRAY_TOP.xCOL10.qb40)	= 0.7v
.ic v(XARRAY_TOP.xCOL11.q40)	= 0v
.ic v(XARRAY_TOP.xCOL11.qb40)	= 0.7v
.ic v(XARRAY_TOP.xCOL12.q40)	= 0v
.ic v(XARRAY_TOP.xCOL12.qb40)	= 0.7v
.ic v(XARRAY_TOP.xCOL13.q40)	= 0v
.ic v(XARRAY_TOP.xCOL13.qb40)	= 0.7v
.ic v(XARRAY_TOP.xCOL14.q40)	= 0v
.ic v(XARRAY_TOP.xCOL14.qb40)	= 0.7v
.ic v(XARRAY_TOP.xCOL15.q40)	= 0v
.ic v(XARRAY_TOP.xCOL15.qb40)	= 0.7v
.ic v(XARRAY_TOP.xCOL16.q40)	= 0v
.ic v(XARRAY_TOP.xCOL16.qb40)	= 0.7v
.ic v(XARRAY_TOP.xCOL17.q40)	= 0v
.ic v(XARRAY_TOP.xCOL17.qb40)	= 0.7v
.ic v(XARRAY_TOP.xCOL18.q40)	= 0v
.ic v(XARRAY_TOP.xCOL18.qb40)	= 0.7v
.ic v(XARRAY_TOP.xCOL19.q40)	= 0v
.ic v(XARRAY_TOP.xCOL19.qb40)	= 0.7v
.ic v(XARRAY_TOP.xCOL20.q40)	= 0v
.ic v(XARRAY_TOP.xCOL20.qb40)	= 0.7v
.ic v(XARRAY_TOP.xCOL21.q40)	= 0v
.ic v(XARRAY_TOP.xCOL21.qb40)	= 0.7v
.ic v(XARRAY_TOP.xCOL22.q40)	= 0v
.ic v(XARRAY_TOP.xCOL22.qb40)	= 0.7v
.ic v(XARRAY_TOP.xCOL23.q40)	= 0v
.ic v(XARRAY_TOP.xCOL23.qb40)	= 0.7v
.ic v(XARRAY_TOP.xCOL24.q40)	= 0v
.ic v(XARRAY_TOP.xCOL24.qb40)	= 0.7v
.ic v(XARRAY_TOP.xCOL25.q40)	= 0v
.ic v(XARRAY_TOP.xCOL25.qb40)	= 0.7v
.ic v(XARRAY_TOP.xCOL26.q40)	= 0v
.ic v(XARRAY_TOP.xCOL26.qb40)	= 0.7v
.ic v(XARRAY_TOP.xCOL27.q40)	= 0v
.ic v(XARRAY_TOP.xCOL27.qb40)	= 0.7v
.ic v(XARRAY_TOP.xCOL28.q40)	= 0v
.ic v(XARRAY_TOP.xCOL28.qb40)	= 0.7v
.ic v(XARRAY_TOP.xCOL29.q40)	= 0v
.ic v(XARRAY_TOP.xCOL29.qb40)	= 0.7v
.ic v(XARRAY_TOP.xCOL30.q40)	= 0v
.ic v(XARRAY_TOP.xCOL30.qb40)	= 0.7v
.ic v(XARRAY_TOP.xCOL31.q40)	= 0v
.ic v(XARRAY_TOP.xCOL31.qb40)	= 0.7v
.ic v(XARRAY_TOP.xCOL0.q41)	= 0v
.ic v(XARRAY_TOP.xCOL0.qb41)	= 0.7v
.ic v(XARRAY_TOP.xCOL1.q41)	= 0v
.ic v(XARRAY_TOP.xCOL1.qb41)	= 0.7v
.ic v(XARRAY_TOP.xCOL2.q41)	= 0v
.ic v(XARRAY_TOP.xCOL2.qb41)	= 0.7v
.ic v(XARRAY_TOP.xCOL3.q41)	= 0v
.ic v(XARRAY_TOP.xCOL3.qb41)	= 0.7v
.ic v(XARRAY_TOP.xCOL4.q41)	= 0v
.ic v(XARRAY_TOP.xCOL4.qb41)	= 0.7v
.ic v(XARRAY_TOP.xCOL5.q41)	= 0v
.ic v(XARRAY_TOP.xCOL5.qb41)	= 0.7v
.ic v(XARRAY_TOP.xCOL6.q41)	= 0v
.ic v(XARRAY_TOP.xCOL6.qb41)	= 0.7v
.ic v(XARRAY_TOP.xCOL7.q41)	= 0v
.ic v(XARRAY_TOP.xCOL7.qb41)	= 0.7v
.ic v(XARRAY_TOP.xCOL8.q41)	= 0v
.ic v(XARRAY_TOP.xCOL8.qb41)	= 0.7v
.ic v(XARRAY_TOP.xCOL9.q41)	= 0v
.ic v(XARRAY_TOP.xCOL9.qb41)	= 0.7v
.ic v(XARRAY_TOP.xCOL10.q41)	= 0v
.ic v(XARRAY_TOP.xCOL10.qb41)	= 0.7v
.ic v(XARRAY_TOP.xCOL11.q41)	= 0v
.ic v(XARRAY_TOP.xCOL11.qb41)	= 0.7v
.ic v(XARRAY_TOP.xCOL12.q41)	= 0v
.ic v(XARRAY_TOP.xCOL12.qb41)	= 0.7v
.ic v(XARRAY_TOP.xCOL13.q41)	= 0v
.ic v(XARRAY_TOP.xCOL13.qb41)	= 0.7v
.ic v(XARRAY_TOP.xCOL14.q41)	= 0v
.ic v(XARRAY_TOP.xCOL14.qb41)	= 0.7v
.ic v(XARRAY_TOP.xCOL15.q41)	= 0v
.ic v(XARRAY_TOP.xCOL15.qb41)	= 0.7v
.ic v(XARRAY_TOP.xCOL16.q41)	= 0v
.ic v(XARRAY_TOP.xCOL16.qb41)	= 0.7v
.ic v(XARRAY_TOP.xCOL17.q41)	= 0v
.ic v(XARRAY_TOP.xCOL17.qb41)	= 0.7v
.ic v(XARRAY_TOP.xCOL18.q41)	= 0v
.ic v(XARRAY_TOP.xCOL18.qb41)	= 0.7v
.ic v(XARRAY_TOP.xCOL19.q41)	= 0v
.ic v(XARRAY_TOP.xCOL19.qb41)	= 0.7v
.ic v(XARRAY_TOP.xCOL20.q41)	= 0v
.ic v(XARRAY_TOP.xCOL20.qb41)	= 0.7v
.ic v(XARRAY_TOP.xCOL21.q41)	= 0v
.ic v(XARRAY_TOP.xCOL21.qb41)	= 0.7v
.ic v(XARRAY_TOP.xCOL22.q41)	= 0v
.ic v(XARRAY_TOP.xCOL22.qb41)	= 0.7v
.ic v(XARRAY_TOP.xCOL23.q41)	= 0v
.ic v(XARRAY_TOP.xCOL23.qb41)	= 0.7v
.ic v(XARRAY_TOP.xCOL24.q41)	= 0v
.ic v(XARRAY_TOP.xCOL24.qb41)	= 0.7v
.ic v(XARRAY_TOP.xCOL25.q41)	= 0v
.ic v(XARRAY_TOP.xCOL25.qb41)	= 0.7v
.ic v(XARRAY_TOP.xCOL26.q41)	= 0v
.ic v(XARRAY_TOP.xCOL26.qb41)	= 0.7v
.ic v(XARRAY_TOP.xCOL27.q41)	= 0v
.ic v(XARRAY_TOP.xCOL27.qb41)	= 0.7v
.ic v(XARRAY_TOP.xCOL28.q41)	= 0v
.ic v(XARRAY_TOP.xCOL28.qb41)	= 0.7v
.ic v(XARRAY_TOP.xCOL29.q41)	= 0v
.ic v(XARRAY_TOP.xCOL29.qb41)	= 0.7v
.ic v(XARRAY_TOP.xCOL30.q41)	= 0v
.ic v(XARRAY_TOP.xCOL30.qb41)	= 0.7v
.ic v(XARRAY_TOP.xCOL31.q41)	= 0v
.ic v(XARRAY_TOP.xCOL31.qb41)	= 0.7v
.ic v(XARRAY_TOP.xCOL0.q42)	= 0v
.ic v(XARRAY_TOP.xCOL0.qb42)	= 0.7v
.ic v(XARRAY_TOP.xCOL1.q42)	= 0v
.ic v(XARRAY_TOP.xCOL1.qb42)	= 0.7v
.ic v(XARRAY_TOP.xCOL2.q42)	= 0v
.ic v(XARRAY_TOP.xCOL2.qb42)	= 0.7v
.ic v(XARRAY_TOP.xCOL3.q42)	= 0v
.ic v(XARRAY_TOP.xCOL3.qb42)	= 0.7v
.ic v(XARRAY_TOP.xCOL4.q42)	= 0v
.ic v(XARRAY_TOP.xCOL4.qb42)	= 0.7v
.ic v(XARRAY_TOP.xCOL5.q42)	= 0v
.ic v(XARRAY_TOP.xCOL5.qb42)	= 0.7v
.ic v(XARRAY_TOP.xCOL6.q42)	= 0v
.ic v(XARRAY_TOP.xCOL6.qb42)	= 0.7v
.ic v(XARRAY_TOP.xCOL7.q42)	= 0v
.ic v(XARRAY_TOP.xCOL7.qb42)	= 0.7v
.ic v(XARRAY_TOP.xCOL8.q42)	= 0v
.ic v(XARRAY_TOP.xCOL8.qb42)	= 0.7v
.ic v(XARRAY_TOP.xCOL9.q42)	= 0v
.ic v(XARRAY_TOP.xCOL9.qb42)	= 0.7v
.ic v(XARRAY_TOP.xCOL10.q42)	= 0v
.ic v(XARRAY_TOP.xCOL10.qb42)	= 0.7v
.ic v(XARRAY_TOP.xCOL11.q42)	= 0v
.ic v(XARRAY_TOP.xCOL11.qb42)	= 0.7v
.ic v(XARRAY_TOP.xCOL12.q42)	= 0v
.ic v(XARRAY_TOP.xCOL12.qb42)	= 0.7v
.ic v(XARRAY_TOP.xCOL13.q42)	= 0v
.ic v(XARRAY_TOP.xCOL13.qb42)	= 0.7v
.ic v(XARRAY_TOP.xCOL14.q42)	= 0v
.ic v(XARRAY_TOP.xCOL14.qb42)	= 0.7v
.ic v(XARRAY_TOP.xCOL15.q42)	= 0v
.ic v(XARRAY_TOP.xCOL15.qb42)	= 0.7v
.ic v(XARRAY_TOP.xCOL16.q42)	= 0v
.ic v(XARRAY_TOP.xCOL16.qb42)	= 0.7v
.ic v(XARRAY_TOP.xCOL17.q42)	= 0v
.ic v(XARRAY_TOP.xCOL17.qb42)	= 0.7v
.ic v(XARRAY_TOP.xCOL18.q42)	= 0v
.ic v(XARRAY_TOP.xCOL18.qb42)	= 0.7v
.ic v(XARRAY_TOP.xCOL19.q42)	= 0v
.ic v(XARRAY_TOP.xCOL19.qb42)	= 0.7v
.ic v(XARRAY_TOP.xCOL20.q42)	= 0v
.ic v(XARRAY_TOP.xCOL20.qb42)	= 0.7v
.ic v(XARRAY_TOP.xCOL21.q42)	= 0v
.ic v(XARRAY_TOP.xCOL21.qb42)	= 0.7v
.ic v(XARRAY_TOP.xCOL22.q42)	= 0v
.ic v(XARRAY_TOP.xCOL22.qb42)	= 0.7v
.ic v(XARRAY_TOP.xCOL23.q42)	= 0v
.ic v(XARRAY_TOP.xCOL23.qb42)	= 0.7v
.ic v(XARRAY_TOP.xCOL24.q42)	= 0v
.ic v(XARRAY_TOP.xCOL24.qb42)	= 0.7v
.ic v(XARRAY_TOP.xCOL25.q42)	= 0v
.ic v(XARRAY_TOP.xCOL25.qb42)	= 0.7v
.ic v(XARRAY_TOP.xCOL26.q42)	= 0v
.ic v(XARRAY_TOP.xCOL26.qb42)	= 0.7v
.ic v(XARRAY_TOP.xCOL27.q42)	= 0v
.ic v(XARRAY_TOP.xCOL27.qb42)	= 0.7v
.ic v(XARRAY_TOP.xCOL28.q42)	= 0v
.ic v(XARRAY_TOP.xCOL28.qb42)	= 0.7v
.ic v(XARRAY_TOP.xCOL29.q42)	= 0v
.ic v(XARRAY_TOP.xCOL29.qb42)	= 0.7v
.ic v(XARRAY_TOP.xCOL30.q42)	= 0v
.ic v(XARRAY_TOP.xCOL30.qb42)	= 0.7v
.ic v(XARRAY_TOP.xCOL31.q42)	= 0v
.ic v(XARRAY_TOP.xCOL31.qb42)	= 0.7v
.ic v(XARRAY_TOP.xCOL0.q43)	= 0v
.ic v(XARRAY_TOP.xCOL0.qb43)	= 0.7v
.ic v(XARRAY_TOP.xCOL1.q43)	= 0v
.ic v(XARRAY_TOP.xCOL1.qb43)	= 0.7v
.ic v(XARRAY_TOP.xCOL2.q43)	= 0v
.ic v(XARRAY_TOP.xCOL2.qb43)	= 0.7v
.ic v(XARRAY_TOP.xCOL3.q43)	= 0v
.ic v(XARRAY_TOP.xCOL3.qb43)	= 0.7v
.ic v(XARRAY_TOP.xCOL4.q43)	= 0v
.ic v(XARRAY_TOP.xCOL4.qb43)	= 0.7v
.ic v(XARRAY_TOP.xCOL5.q43)	= 0v
.ic v(XARRAY_TOP.xCOL5.qb43)	= 0.7v
.ic v(XARRAY_TOP.xCOL6.q43)	= 0v
.ic v(XARRAY_TOP.xCOL6.qb43)	= 0.7v
.ic v(XARRAY_TOP.xCOL7.q43)	= 0v
.ic v(XARRAY_TOP.xCOL7.qb43)	= 0.7v
.ic v(XARRAY_TOP.xCOL8.q43)	= 0v
.ic v(XARRAY_TOP.xCOL8.qb43)	= 0.7v
.ic v(XARRAY_TOP.xCOL9.q43)	= 0v
.ic v(XARRAY_TOP.xCOL9.qb43)	= 0.7v
.ic v(XARRAY_TOP.xCOL10.q43)	= 0v
.ic v(XARRAY_TOP.xCOL10.qb43)	= 0.7v
.ic v(XARRAY_TOP.xCOL11.q43)	= 0v
.ic v(XARRAY_TOP.xCOL11.qb43)	= 0.7v
.ic v(XARRAY_TOP.xCOL12.q43)	= 0v
.ic v(XARRAY_TOP.xCOL12.qb43)	= 0.7v
.ic v(XARRAY_TOP.xCOL13.q43)	= 0v
.ic v(XARRAY_TOP.xCOL13.qb43)	= 0.7v
.ic v(XARRAY_TOP.xCOL14.q43)	= 0v
.ic v(XARRAY_TOP.xCOL14.qb43)	= 0.7v
.ic v(XARRAY_TOP.xCOL15.q43)	= 0v
.ic v(XARRAY_TOP.xCOL15.qb43)	= 0.7v
.ic v(XARRAY_TOP.xCOL16.q43)	= 0v
.ic v(XARRAY_TOP.xCOL16.qb43)	= 0.7v
.ic v(XARRAY_TOP.xCOL17.q43)	= 0v
.ic v(XARRAY_TOP.xCOL17.qb43)	= 0.7v
.ic v(XARRAY_TOP.xCOL18.q43)	= 0v
.ic v(XARRAY_TOP.xCOL18.qb43)	= 0.7v
.ic v(XARRAY_TOP.xCOL19.q43)	= 0v
.ic v(XARRAY_TOP.xCOL19.qb43)	= 0.7v
.ic v(XARRAY_TOP.xCOL20.q43)	= 0v
.ic v(XARRAY_TOP.xCOL20.qb43)	= 0.7v
.ic v(XARRAY_TOP.xCOL21.q43)	= 0v
.ic v(XARRAY_TOP.xCOL21.qb43)	= 0.7v
.ic v(XARRAY_TOP.xCOL22.q43)	= 0v
.ic v(XARRAY_TOP.xCOL22.qb43)	= 0.7v
.ic v(XARRAY_TOP.xCOL23.q43)	= 0v
.ic v(XARRAY_TOP.xCOL23.qb43)	= 0.7v
.ic v(XARRAY_TOP.xCOL24.q43)	= 0v
.ic v(XARRAY_TOP.xCOL24.qb43)	= 0.7v
.ic v(XARRAY_TOP.xCOL25.q43)	= 0v
.ic v(XARRAY_TOP.xCOL25.qb43)	= 0.7v
.ic v(XARRAY_TOP.xCOL26.q43)	= 0v
.ic v(XARRAY_TOP.xCOL26.qb43)	= 0.7v
.ic v(XARRAY_TOP.xCOL27.q43)	= 0v
.ic v(XARRAY_TOP.xCOL27.qb43)	= 0.7v
.ic v(XARRAY_TOP.xCOL28.q43)	= 0v
.ic v(XARRAY_TOP.xCOL28.qb43)	= 0.7v
.ic v(XARRAY_TOP.xCOL29.q43)	= 0v
.ic v(XARRAY_TOP.xCOL29.qb43)	= 0.7v
.ic v(XARRAY_TOP.xCOL30.q43)	= 0v
.ic v(XARRAY_TOP.xCOL30.qb43)	= 0.7v
.ic v(XARRAY_TOP.xCOL31.q43)	= 0v
.ic v(XARRAY_TOP.xCOL31.qb43)	= 0.7v
.ic v(XARRAY_TOP.xCOL0.q44)	= 0v
.ic v(XARRAY_TOP.xCOL0.qb44)	= 0.7v
.ic v(XARRAY_TOP.xCOL1.q44)	= 0v
.ic v(XARRAY_TOP.xCOL1.qb44)	= 0.7v
.ic v(XARRAY_TOP.xCOL2.q44)	= 0v
.ic v(XARRAY_TOP.xCOL2.qb44)	= 0.7v
.ic v(XARRAY_TOP.xCOL3.q44)	= 0v
.ic v(XARRAY_TOP.xCOL3.qb44)	= 0.7v
.ic v(XARRAY_TOP.xCOL4.q44)	= 0v
.ic v(XARRAY_TOP.xCOL4.qb44)	= 0.7v
.ic v(XARRAY_TOP.xCOL5.q44)	= 0v
.ic v(XARRAY_TOP.xCOL5.qb44)	= 0.7v
.ic v(XARRAY_TOP.xCOL6.q44)	= 0v
.ic v(XARRAY_TOP.xCOL6.qb44)	= 0.7v
.ic v(XARRAY_TOP.xCOL7.q44)	= 0v
.ic v(XARRAY_TOP.xCOL7.qb44)	= 0.7v
.ic v(XARRAY_TOP.xCOL8.q44)	= 0v
.ic v(XARRAY_TOP.xCOL8.qb44)	= 0.7v
.ic v(XARRAY_TOP.xCOL9.q44)	= 0v
.ic v(XARRAY_TOP.xCOL9.qb44)	= 0.7v
.ic v(XARRAY_TOP.xCOL10.q44)	= 0v
.ic v(XARRAY_TOP.xCOL10.qb44)	= 0.7v
.ic v(XARRAY_TOP.xCOL11.q44)	= 0v
.ic v(XARRAY_TOP.xCOL11.qb44)	= 0.7v
.ic v(XARRAY_TOP.xCOL12.q44)	= 0v
.ic v(XARRAY_TOP.xCOL12.qb44)	= 0.7v
.ic v(XARRAY_TOP.xCOL13.q44)	= 0v
.ic v(XARRAY_TOP.xCOL13.qb44)	= 0.7v
.ic v(XARRAY_TOP.xCOL14.q44)	= 0v
.ic v(XARRAY_TOP.xCOL14.qb44)	= 0.7v
.ic v(XARRAY_TOP.xCOL15.q44)	= 0v
.ic v(XARRAY_TOP.xCOL15.qb44)	= 0.7v
.ic v(XARRAY_TOP.xCOL16.q44)	= 0v
.ic v(XARRAY_TOP.xCOL16.qb44)	= 0.7v
.ic v(XARRAY_TOP.xCOL17.q44)	= 0v
.ic v(XARRAY_TOP.xCOL17.qb44)	= 0.7v
.ic v(XARRAY_TOP.xCOL18.q44)	= 0v
.ic v(XARRAY_TOP.xCOL18.qb44)	= 0.7v
.ic v(XARRAY_TOP.xCOL19.q44)	= 0v
.ic v(XARRAY_TOP.xCOL19.qb44)	= 0.7v
.ic v(XARRAY_TOP.xCOL20.q44)	= 0v
.ic v(XARRAY_TOP.xCOL20.qb44)	= 0.7v
.ic v(XARRAY_TOP.xCOL21.q44)	= 0v
.ic v(XARRAY_TOP.xCOL21.qb44)	= 0.7v
.ic v(XARRAY_TOP.xCOL22.q44)	= 0v
.ic v(XARRAY_TOP.xCOL22.qb44)	= 0.7v
.ic v(XARRAY_TOP.xCOL23.q44)	= 0v
.ic v(XARRAY_TOP.xCOL23.qb44)	= 0.7v
.ic v(XARRAY_TOP.xCOL24.q44)	= 0v
.ic v(XARRAY_TOP.xCOL24.qb44)	= 0.7v
.ic v(XARRAY_TOP.xCOL25.q44)	= 0v
.ic v(XARRAY_TOP.xCOL25.qb44)	= 0.7v
.ic v(XARRAY_TOP.xCOL26.q44)	= 0v
.ic v(XARRAY_TOP.xCOL26.qb44)	= 0.7v
.ic v(XARRAY_TOP.xCOL27.q44)	= 0v
.ic v(XARRAY_TOP.xCOL27.qb44)	= 0.7v
.ic v(XARRAY_TOP.xCOL28.q44)	= 0v
.ic v(XARRAY_TOP.xCOL28.qb44)	= 0.7v
.ic v(XARRAY_TOP.xCOL29.q44)	= 0v
.ic v(XARRAY_TOP.xCOL29.qb44)	= 0.7v
.ic v(XARRAY_TOP.xCOL30.q44)	= 0v
.ic v(XARRAY_TOP.xCOL30.qb44)	= 0.7v
.ic v(XARRAY_TOP.xCOL31.q44)	= 0v
.ic v(XARRAY_TOP.xCOL31.qb44)	= 0.7v
.ic v(XARRAY_TOP.xCOL0.q45)	= 0v
.ic v(XARRAY_TOP.xCOL0.qb45)	= 0.7v
.ic v(XARRAY_TOP.xCOL1.q45)	= 0v
.ic v(XARRAY_TOP.xCOL1.qb45)	= 0.7v
.ic v(XARRAY_TOP.xCOL2.q45)	= 0v
.ic v(XARRAY_TOP.xCOL2.qb45)	= 0.7v
.ic v(XARRAY_TOP.xCOL3.q45)	= 0v
.ic v(XARRAY_TOP.xCOL3.qb45)	= 0.7v
.ic v(XARRAY_TOP.xCOL4.q45)	= 0v
.ic v(XARRAY_TOP.xCOL4.qb45)	= 0.7v
.ic v(XARRAY_TOP.xCOL5.q45)	= 0v
.ic v(XARRAY_TOP.xCOL5.qb45)	= 0.7v
.ic v(XARRAY_TOP.xCOL6.q45)	= 0v
.ic v(XARRAY_TOP.xCOL6.qb45)	= 0.7v
.ic v(XARRAY_TOP.xCOL7.q45)	= 0v
.ic v(XARRAY_TOP.xCOL7.qb45)	= 0.7v
.ic v(XARRAY_TOP.xCOL8.q45)	= 0v
.ic v(XARRAY_TOP.xCOL8.qb45)	= 0.7v
.ic v(XARRAY_TOP.xCOL9.q45)	= 0v
.ic v(XARRAY_TOP.xCOL9.qb45)	= 0.7v
.ic v(XARRAY_TOP.xCOL10.q45)	= 0v
.ic v(XARRAY_TOP.xCOL10.qb45)	= 0.7v
.ic v(XARRAY_TOP.xCOL11.q45)	= 0v
.ic v(XARRAY_TOP.xCOL11.qb45)	= 0.7v
.ic v(XARRAY_TOP.xCOL12.q45)	= 0v
.ic v(XARRAY_TOP.xCOL12.qb45)	= 0.7v
.ic v(XARRAY_TOP.xCOL13.q45)	= 0v
.ic v(XARRAY_TOP.xCOL13.qb45)	= 0.7v
.ic v(XARRAY_TOP.xCOL14.q45)	= 0v
.ic v(XARRAY_TOP.xCOL14.qb45)	= 0.7v
.ic v(XARRAY_TOP.xCOL15.q45)	= 0v
.ic v(XARRAY_TOP.xCOL15.qb45)	= 0.7v
.ic v(XARRAY_TOP.xCOL16.q45)	= 0v
.ic v(XARRAY_TOP.xCOL16.qb45)	= 0.7v
.ic v(XARRAY_TOP.xCOL17.q45)	= 0v
.ic v(XARRAY_TOP.xCOL17.qb45)	= 0.7v
.ic v(XARRAY_TOP.xCOL18.q45)	= 0v
.ic v(XARRAY_TOP.xCOL18.qb45)	= 0.7v
.ic v(XARRAY_TOP.xCOL19.q45)	= 0v
.ic v(XARRAY_TOP.xCOL19.qb45)	= 0.7v
.ic v(XARRAY_TOP.xCOL20.q45)	= 0v
.ic v(XARRAY_TOP.xCOL20.qb45)	= 0.7v
.ic v(XARRAY_TOP.xCOL21.q45)	= 0v
.ic v(XARRAY_TOP.xCOL21.qb45)	= 0.7v
.ic v(XARRAY_TOP.xCOL22.q45)	= 0v
.ic v(XARRAY_TOP.xCOL22.qb45)	= 0.7v
.ic v(XARRAY_TOP.xCOL23.q45)	= 0v
.ic v(XARRAY_TOP.xCOL23.qb45)	= 0.7v
.ic v(XARRAY_TOP.xCOL24.q45)	= 0v
.ic v(XARRAY_TOP.xCOL24.qb45)	= 0.7v
.ic v(XARRAY_TOP.xCOL25.q45)	= 0v
.ic v(XARRAY_TOP.xCOL25.qb45)	= 0.7v
.ic v(XARRAY_TOP.xCOL26.q45)	= 0v
.ic v(XARRAY_TOP.xCOL26.qb45)	= 0.7v
.ic v(XARRAY_TOP.xCOL27.q45)	= 0v
.ic v(XARRAY_TOP.xCOL27.qb45)	= 0.7v
.ic v(XARRAY_TOP.xCOL28.q45)	= 0v
.ic v(XARRAY_TOP.xCOL28.qb45)	= 0.7v
.ic v(XARRAY_TOP.xCOL29.q45)	= 0v
.ic v(XARRAY_TOP.xCOL29.qb45)	= 0.7v
.ic v(XARRAY_TOP.xCOL30.q45)	= 0v
.ic v(XARRAY_TOP.xCOL30.qb45)	= 0.7v
.ic v(XARRAY_TOP.xCOL31.q45)	= 0v
.ic v(XARRAY_TOP.xCOL31.qb45)	= 0.7v
.ic v(XARRAY_TOP.xCOL0.q46)	= 0v
.ic v(XARRAY_TOP.xCOL0.qb46)	= 0.7v
.ic v(XARRAY_TOP.xCOL1.q46)	= 0v
.ic v(XARRAY_TOP.xCOL1.qb46)	= 0.7v
.ic v(XARRAY_TOP.xCOL2.q46)	= 0v
.ic v(XARRAY_TOP.xCOL2.qb46)	= 0.7v
.ic v(XARRAY_TOP.xCOL3.q46)	= 0v
.ic v(XARRAY_TOP.xCOL3.qb46)	= 0.7v
.ic v(XARRAY_TOP.xCOL4.q46)	= 0v
.ic v(XARRAY_TOP.xCOL4.qb46)	= 0.7v
.ic v(XARRAY_TOP.xCOL5.q46)	= 0v
.ic v(XARRAY_TOP.xCOL5.qb46)	= 0.7v
.ic v(XARRAY_TOP.xCOL6.q46)	= 0v
.ic v(XARRAY_TOP.xCOL6.qb46)	= 0.7v
.ic v(XARRAY_TOP.xCOL7.q46)	= 0v
.ic v(XARRAY_TOP.xCOL7.qb46)	= 0.7v
.ic v(XARRAY_TOP.xCOL8.q46)	= 0v
.ic v(XARRAY_TOP.xCOL8.qb46)	= 0.7v
.ic v(XARRAY_TOP.xCOL9.q46)	= 0v
.ic v(XARRAY_TOP.xCOL9.qb46)	= 0.7v
.ic v(XARRAY_TOP.xCOL10.q46)	= 0v
.ic v(XARRAY_TOP.xCOL10.qb46)	= 0.7v
.ic v(XARRAY_TOP.xCOL11.q46)	= 0v
.ic v(XARRAY_TOP.xCOL11.qb46)	= 0.7v
.ic v(XARRAY_TOP.xCOL12.q46)	= 0v
.ic v(XARRAY_TOP.xCOL12.qb46)	= 0.7v
.ic v(XARRAY_TOP.xCOL13.q46)	= 0v
.ic v(XARRAY_TOP.xCOL13.qb46)	= 0.7v
.ic v(XARRAY_TOP.xCOL14.q46)	= 0v
.ic v(XARRAY_TOP.xCOL14.qb46)	= 0.7v
.ic v(XARRAY_TOP.xCOL15.q46)	= 0v
.ic v(XARRAY_TOP.xCOL15.qb46)	= 0.7v
.ic v(XARRAY_TOP.xCOL16.q46)	= 0v
.ic v(XARRAY_TOP.xCOL16.qb46)	= 0.7v
.ic v(XARRAY_TOP.xCOL17.q46)	= 0v
.ic v(XARRAY_TOP.xCOL17.qb46)	= 0.7v
.ic v(XARRAY_TOP.xCOL18.q46)	= 0v
.ic v(XARRAY_TOP.xCOL18.qb46)	= 0.7v
.ic v(XARRAY_TOP.xCOL19.q46)	= 0v
.ic v(XARRAY_TOP.xCOL19.qb46)	= 0.7v
.ic v(XARRAY_TOP.xCOL20.q46)	= 0v
.ic v(XARRAY_TOP.xCOL20.qb46)	= 0.7v
.ic v(XARRAY_TOP.xCOL21.q46)	= 0v
.ic v(XARRAY_TOP.xCOL21.qb46)	= 0.7v
.ic v(XARRAY_TOP.xCOL22.q46)	= 0v
.ic v(XARRAY_TOP.xCOL22.qb46)	= 0.7v
.ic v(XARRAY_TOP.xCOL23.q46)	= 0v
.ic v(XARRAY_TOP.xCOL23.qb46)	= 0.7v
.ic v(XARRAY_TOP.xCOL24.q46)	= 0v
.ic v(XARRAY_TOP.xCOL24.qb46)	= 0.7v
.ic v(XARRAY_TOP.xCOL25.q46)	= 0v
.ic v(XARRAY_TOP.xCOL25.qb46)	= 0.7v
.ic v(XARRAY_TOP.xCOL26.q46)	= 0v
.ic v(XARRAY_TOP.xCOL26.qb46)	= 0.7v
.ic v(XARRAY_TOP.xCOL27.q46)	= 0v
.ic v(XARRAY_TOP.xCOL27.qb46)	= 0.7v
.ic v(XARRAY_TOP.xCOL28.q46)	= 0v
.ic v(XARRAY_TOP.xCOL28.qb46)	= 0.7v
.ic v(XARRAY_TOP.xCOL29.q46)	= 0v
.ic v(XARRAY_TOP.xCOL29.qb46)	= 0.7v
.ic v(XARRAY_TOP.xCOL30.q46)	= 0v
.ic v(XARRAY_TOP.xCOL30.qb46)	= 0.7v
.ic v(XARRAY_TOP.xCOL31.q46)	= 0v
.ic v(XARRAY_TOP.xCOL31.qb46)	= 0.7v
.ic v(XARRAY_TOP.xCOL0.q47)	= 0v
.ic v(XARRAY_TOP.xCOL0.qb47)	= 0.7v
.ic v(XARRAY_TOP.xCOL1.q47)	= 0v
.ic v(XARRAY_TOP.xCOL1.qb47)	= 0.7v
.ic v(XARRAY_TOP.xCOL2.q47)	= 0v
.ic v(XARRAY_TOP.xCOL2.qb47)	= 0.7v
.ic v(XARRAY_TOP.xCOL3.q47)	= 0v
.ic v(XARRAY_TOP.xCOL3.qb47)	= 0.7v
.ic v(XARRAY_TOP.xCOL4.q47)	= 0v
.ic v(XARRAY_TOP.xCOL4.qb47)	= 0.7v
.ic v(XARRAY_TOP.xCOL5.q47)	= 0v
.ic v(XARRAY_TOP.xCOL5.qb47)	= 0.7v
.ic v(XARRAY_TOP.xCOL6.q47)	= 0v
.ic v(XARRAY_TOP.xCOL6.qb47)	= 0.7v
.ic v(XARRAY_TOP.xCOL7.q47)	= 0v
.ic v(XARRAY_TOP.xCOL7.qb47)	= 0.7v
.ic v(XARRAY_TOP.xCOL8.q47)	= 0v
.ic v(XARRAY_TOP.xCOL8.qb47)	= 0.7v
.ic v(XARRAY_TOP.xCOL9.q47)	= 0v
.ic v(XARRAY_TOP.xCOL9.qb47)	= 0.7v
.ic v(XARRAY_TOP.xCOL10.q47)	= 0v
.ic v(XARRAY_TOP.xCOL10.qb47)	= 0.7v
.ic v(XARRAY_TOP.xCOL11.q47)	= 0v
.ic v(XARRAY_TOP.xCOL11.qb47)	= 0.7v
.ic v(XARRAY_TOP.xCOL12.q47)	= 0v
.ic v(XARRAY_TOP.xCOL12.qb47)	= 0.7v
.ic v(XARRAY_TOP.xCOL13.q47)	= 0v
.ic v(XARRAY_TOP.xCOL13.qb47)	= 0.7v
.ic v(XARRAY_TOP.xCOL14.q47)	= 0v
.ic v(XARRAY_TOP.xCOL14.qb47)	= 0.7v
.ic v(XARRAY_TOP.xCOL15.q47)	= 0v
.ic v(XARRAY_TOP.xCOL15.qb47)	= 0.7v
.ic v(XARRAY_TOP.xCOL16.q47)	= 0v
.ic v(XARRAY_TOP.xCOL16.qb47)	= 0.7v
.ic v(XARRAY_TOP.xCOL17.q47)	= 0v
.ic v(XARRAY_TOP.xCOL17.qb47)	= 0.7v
.ic v(XARRAY_TOP.xCOL18.q47)	= 0v
.ic v(XARRAY_TOP.xCOL18.qb47)	= 0.7v
.ic v(XARRAY_TOP.xCOL19.q47)	= 0v
.ic v(XARRAY_TOP.xCOL19.qb47)	= 0.7v
.ic v(XARRAY_TOP.xCOL20.q47)	= 0v
.ic v(XARRAY_TOP.xCOL20.qb47)	= 0.7v
.ic v(XARRAY_TOP.xCOL21.q47)	= 0v
.ic v(XARRAY_TOP.xCOL21.qb47)	= 0.7v
.ic v(XARRAY_TOP.xCOL22.q47)	= 0v
.ic v(XARRAY_TOP.xCOL22.qb47)	= 0.7v
.ic v(XARRAY_TOP.xCOL23.q47)	= 0v
.ic v(XARRAY_TOP.xCOL23.qb47)	= 0.7v
.ic v(XARRAY_TOP.xCOL24.q47)	= 0v
.ic v(XARRAY_TOP.xCOL24.qb47)	= 0.7v
.ic v(XARRAY_TOP.xCOL25.q47)	= 0v
.ic v(XARRAY_TOP.xCOL25.qb47)	= 0.7v
.ic v(XARRAY_TOP.xCOL26.q47)	= 0v
.ic v(XARRAY_TOP.xCOL26.qb47)	= 0.7v
.ic v(XARRAY_TOP.xCOL27.q47)	= 0v
.ic v(XARRAY_TOP.xCOL27.qb47)	= 0.7v
.ic v(XARRAY_TOP.xCOL28.q47)	= 0v
.ic v(XARRAY_TOP.xCOL28.qb47)	= 0.7v
.ic v(XARRAY_TOP.xCOL29.q47)	= 0v
.ic v(XARRAY_TOP.xCOL29.qb47)	= 0.7v
.ic v(XARRAY_TOP.xCOL30.q47)	= 0v
.ic v(XARRAY_TOP.xCOL30.qb47)	= 0.7v
.ic v(XARRAY_TOP.xCOL31.q47)	= 0v
.ic v(XARRAY_TOP.xCOL31.qb47)	= 0.7v
.ic v(XARRAY_TOP.xCOL0.q48)	= 0v
.ic v(XARRAY_TOP.xCOL0.qb48)	= 0.7v
.ic v(XARRAY_TOP.xCOL1.q48)	= 0v
.ic v(XARRAY_TOP.xCOL1.qb48)	= 0.7v
.ic v(XARRAY_TOP.xCOL2.q48)	= 0v
.ic v(XARRAY_TOP.xCOL2.qb48)	= 0.7v
.ic v(XARRAY_TOP.xCOL3.q48)	= 0v
.ic v(XARRAY_TOP.xCOL3.qb48)	= 0.7v
.ic v(XARRAY_TOP.xCOL4.q48)	= 0v
.ic v(XARRAY_TOP.xCOL4.qb48)	= 0.7v
.ic v(XARRAY_TOP.xCOL5.q48)	= 0v
.ic v(XARRAY_TOP.xCOL5.qb48)	= 0.7v
.ic v(XARRAY_TOP.xCOL6.q48)	= 0v
.ic v(XARRAY_TOP.xCOL6.qb48)	= 0.7v
.ic v(XARRAY_TOP.xCOL7.q48)	= 0v
.ic v(XARRAY_TOP.xCOL7.qb48)	= 0.7v
.ic v(XARRAY_TOP.xCOL8.q48)	= 0v
.ic v(XARRAY_TOP.xCOL8.qb48)	= 0.7v
.ic v(XARRAY_TOP.xCOL9.q48)	= 0v
.ic v(XARRAY_TOP.xCOL9.qb48)	= 0.7v
.ic v(XARRAY_TOP.xCOL10.q48)	= 0v
.ic v(XARRAY_TOP.xCOL10.qb48)	= 0.7v
.ic v(XARRAY_TOP.xCOL11.q48)	= 0v
.ic v(XARRAY_TOP.xCOL11.qb48)	= 0.7v
.ic v(XARRAY_TOP.xCOL12.q48)	= 0v
.ic v(XARRAY_TOP.xCOL12.qb48)	= 0.7v
.ic v(XARRAY_TOP.xCOL13.q48)	= 0v
.ic v(XARRAY_TOP.xCOL13.qb48)	= 0.7v
.ic v(XARRAY_TOP.xCOL14.q48)	= 0v
.ic v(XARRAY_TOP.xCOL14.qb48)	= 0.7v
.ic v(XARRAY_TOP.xCOL15.q48)	= 0v
.ic v(XARRAY_TOP.xCOL15.qb48)	= 0.7v
.ic v(XARRAY_TOP.xCOL16.q48)	= 0v
.ic v(XARRAY_TOP.xCOL16.qb48)	= 0.7v
.ic v(XARRAY_TOP.xCOL17.q48)	= 0v
.ic v(XARRAY_TOP.xCOL17.qb48)	= 0.7v
.ic v(XARRAY_TOP.xCOL18.q48)	= 0v
.ic v(XARRAY_TOP.xCOL18.qb48)	= 0.7v
.ic v(XARRAY_TOP.xCOL19.q48)	= 0v
.ic v(XARRAY_TOP.xCOL19.qb48)	= 0.7v
.ic v(XARRAY_TOP.xCOL20.q48)	= 0v
.ic v(XARRAY_TOP.xCOL20.qb48)	= 0.7v
.ic v(XARRAY_TOP.xCOL21.q48)	= 0v
.ic v(XARRAY_TOP.xCOL21.qb48)	= 0.7v
.ic v(XARRAY_TOP.xCOL22.q48)	= 0v
.ic v(XARRAY_TOP.xCOL22.qb48)	= 0.7v
.ic v(XARRAY_TOP.xCOL23.q48)	= 0v
.ic v(XARRAY_TOP.xCOL23.qb48)	= 0.7v
.ic v(XARRAY_TOP.xCOL24.q48)	= 0v
.ic v(XARRAY_TOP.xCOL24.qb48)	= 0.7v
.ic v(XARRAY_TOP.xCOL25.q48)	= 0v
.ic v(XARRAY_TOP.xCOL25.qb48)	= 0.7v
.ic v(XARRAY_TOP.xCOL26.q48)	= 0v
.ic v(XARRAY_TOP.xCOL26.qb48)	= 0.7v
.ic v(XARRAY_TOP.xCOL27.q48)	= 0v
.ic v(XARRAY_TOP.xCOL27.qb48)	= 0.7v
.ic v(XARRAY_TOP.xCOL28.q48)	= 0v
.ic v(XARRAY_TOP.xCOL28.qb48)	= 0.7v
.ic v(XARRAY_TOP.xCOL29.q48)	= 0v
.ic v(XARRAY_TOP.xCOL29.qb48)	= 0.7v
.ic v(XARRAY_TOP.xCOL30.q48)	= 0v
.ic v(XARRAY_TOP.xCOL30.qb48)	= 0.7v
.ic v(XARRAY_TOP.xCOL31.q48)	= 0v
.ic v(XARRAY_TOP.xCOL31.qb48)	= 0.7v
.ic v(XARRAY_TOP.xCOL0.q49)	= 0v
.ic v(XARRAY_TOP.xCOL0.qb49)	= 0.7v
.ic v(XARRAY_TOP.xCOL1.q49)	= 0v
.ic v(XARRAY_TOP.xCOL1.qb49)	= 0.7v
.ic v(XARRAY_TOP.xCOL2.q49)	= 0v
.ic v(XARRAY_TOP.xCOL2.qb49)	= 0.7v
.ic v(XARRAY_TOP.xCOL3.q49)	= 0v
.ic v(XARRAY_TOP.xCOL3.qb49)	= 0.7v
.ic v(XARRAY_TOP.xCOL4.q49)	= 0v
.ic v(XARRAY_TOP.xCOL4.qb49)	= 0.7v
.ic v(XARRAY_TOP.xCOL5.q49)	= 0v
.ic v(XARRAY_TOP.xCOL5.qb49)	= 0.7v
.ic v(XARRAY_TOP.xCOL6.q49)	= 0v
.ic v(XARRAY_TOP.xCOL6.qb49)	= 0.7v
.ic v(XARRAY_TOP.xCOL7.q49)	= 0v
.ic v(XARRAY_TOP.xCOL7.qb49)	= 0.7v
.ic v(XARRAY_TOP.xCOL8.q49)	= 0v
.ic v(XARRAY_TOP.xCOL8.qb49)	= 0.7v
.ic v(XARRAY_TOP.xCOL9.q49)	= 0v
.ic v(XARRAY_TOP.xCOL9.qb49)	= 0.7v
.ic v(XARRAY_TOP.xCOL10.q49)	= 0v
.ic v(XARRAY_TOP.xCOL10.qb49)	= 0.7v
.ic v(XARRAY_TOP.xCOL11.q49)	= 0v
.ic v(XARRAY_TOP.xCOL11.qb49)	= 0.7v
.ic v(XARRAY_TOP.xCOL12.q49)	= 0v
.ic v(XARRAY_TOP.xCOL12.qb49)	= 0.7v
.ic v(XARRAY_TOP.xCOL13.q49)	= 0v
.ic v(XARRAY_TOP.xCOL13.qb49)	= 0.7v
.ic v(XARRAY_TOP.xCOL14.q49)	= 0v
.ic v(XARRAY_TOP.xCOL14.qb49)	= 0.7v
.ic v(XARRAY_TOP.xCOL15.q49)	= 0v
.ic v(XARRAY_TOP.xCOL15.qb49)	= 0.7v
.ic v(XARRAY_TOP.xCOL16.q49)	= 0v
.ic v(XARRAY_TOP.xCOL16.qb49)	= 0.7v
.ic v(XARRAY_TOP.xCOL17.q49)	= 0v
.ic v(XARRAY_TOP.xCOL17.qb49)	= 0.7v
.ic v(XARRAY_TOP.xCOL18.q49)	= 0v
.ic v(XARRAY_TOP.xCOL18.qb49)	= 0.7v
.ic v(XARRAY_TOP.xCOL19.q49)	= 0v
.ic v(XARRAY_TOP.xCOL19.qb49)	= 0.7v
.ic v(XARRAY_TOP.xCOL20.q49)	= 0v
.ic v(XARRAY_TOP.xCOL20.qb49)	= 0.7v
.ic v(XARRAY_TOP.xCOL21.q49)	= 0v
.ic v(XARRAY_TOP.xCOL21.qb49)	= 0.7v
.ic v(XARRAY_TOP.xCOL22.q49)	= 0v
.ic v(XARRAY_TOP.xCOL22.qb49)	= 0.7v
.ic v(XARRAY_TOP.xCOL23.q49)	= 0v
.ic v(XARRAY_TOP.xCOL23.qb49)	= 0.7v
.ic v(XARRAY_TOP.xCOL24.q49)	= 0v
.ic v(XARRAY_TOP.xCOL24.qb49)	= 0.7v
.ic v(XARRAY_TOP.xCOL25.q49)	= 0v
.ic v(XARRAY_TOP.xCOL25.qb49)	= 0.7v
.ic v(XARRAY_TOP.xCOL26.q49)	= 0v
.ic v(XARRAY_TOP.xCOL26.qb49)	= 0.7v
.ic v(XARRAY_TOP.xCOL27.q49)	= 0v
.ic v(XARRAY_TOP.xCOL27.qb49)	= 0.7v
.ic v(XARRAY_TOP.xCOL28.q49)	= 0v
.ic v(XARRAY_TOP.xCOL28.qb49)	= 0.7v
.ic v(XARRAY_TOP.xCOL29.q49)	= 0v
.ic v(XARRAY_TOP.xCOL29.qb49)	= 0.7v
.ic v(XARRAY_TOP.xCOL30.q49)	= 0v
.ic v(XARRAY_TOP.xCOL30.qb49)	= 0.7v
.ic v(XARRAY_TOP.xCOL31.q49)	= 0v
.ic v(XARRAY_TOP.xCOL31.qb49)	= 0.7v
.ic v(XARRAY_TOP.xCOL0.q50)	= 0v
.ic v(XARRAY_TOP.xCOL0.qb50)	= 0.7v
.ic v(XARRAY_TOP.xCOL1.q50)	= 0v
.ic v(XARRAY_TOP.xCOL1.qb50)	= 0.7v
.ic v(XARRAY_TOP.xCOL2.q50)	= 0v
.ic v(XARRAY_TOP.xCOL2.qb50)	= 0.7v
.ic v(XARRAY_TOP.xCOL3.q50)	= 0v
.ic v(XARRAY_TOP.xCOL3.qb50)	= 0.7v
.ic v(XARRAY_TOP.xCOL4.q50)	= 0v
.ic v(XARRAY_TOP.xCOL4.qb50)	= 0.7v
.ic v(XARRAY_TOP.xCOL5.q50)	= 0v
.ic v(XARRAY_TOP.xCOL5.qb50)	= 0.7v
.ic v(XARRAY_TOP.xCOL6.q50)	= 0v
.ic v(XARRAY_TOP.xCOL6.qb50)	= 0.7v
.ic v(XARRAY_TOP.xCOL7.q50)	= 0v
.ic v(XARRAY_TOP.xCOL7.qb50)	= 0.7v
.ic v(XARRAY_TOP.xCOL8.q50)	= 0v
.ic v(XARRAY_TOP.xCOL8.qb50)	= 0.7v
.ic v(XARRAY_TOP.xCOL9.q50)	= 0v
.ic v(XARRAY_TOP.xCOL9.qb50)	= 0.7v
.ic v(XARRAY_TOP.xCOL10.q50)	= 0v
.ic v(XARRAY_TOP.xCOL10.qb50)	= 0.7v
.ic v(XARRAY_TOP.xCOL11.q50)	= 0v
.ic v(XARRAY_TOP.xCOL11.qb50)	= 0.7v
.ic v(XARRAY_TOP.xCOL12.q50)	= 0v
.ic v(XARRAY_TOP.xCOL12.qb50)	= 0.7v
.ic v(XARRAY_TOP.xCOL13.q50)	= 0v
.ic v(XARRAY_TOP.xCOL13.qb50)	= 0.7v
.ic v(XARRAY_TOP.xCOL14.q50)	= 0v
.ic v(XARRAY_TOP.xCOL14.qb50)	= 0.7v
.ic v(XARRAY_TOP.xCOL15.q50)	= 0v
.ic v(XARRAY_TOP.xCOL15.qb50)	= 0.7v
.ic v(XARRAY_TOP.xCOL16.q50)	= 0v
.ic v(XARRAY_TOP.xCOL16.qb50)	= 0.7v
.ic v(XARRAY_TOP.xCOL17.q50)	= 0v
.ic v(XARRAY_TOP.xCOL17.qb50)	= 0.7v
.ic v(XARRAY_TOP.xCOL18.q50)	= 0v
.ic v(XARRAY_TOP.xCOL18.qb50)	= 0.7v
.ic v(XARRAY_TOP.xCOL19.q50)	= 0v
.ic v(XARRAY_TOP.xCOL19.qb50)	= 0.7v
.ic v(XARRAY_TOP.xCOL20.q50)	= 0v
.ic v(XARRAY_TOP.xCOL20.qb50)	= 0.7v
.ic v(XARRAY_TOP.xCOL21.q50)	= 0v
.ic v(XARRAY_TOP.xCOL21.qb50)	= 0.7v
.ic v(XARRAY_TOP.xCOL22.q50)	= 0v
.ic v(XARRAY_TOP.xCOL22.qb50)	= 0.7v
.ic v(XARRAY_TOP.xCOL23.q50)	= 0v
.ic v(XARRAY_TOP.xCOL23.qb50)	= 0.7v
.ic v(XARRAY_TOP.xCOL24.q50)	= 0v
.ic v(XARRAY_TOP.xCOL24.qb50)	= 0.7v
.ic v(XARRAY_TOP.xCOL25.q50)	= 0v
.ic v(XARRAY_TOP.xCOL25.qb50)	= 0.7v
.ic v(XARRAY_TOP.xCOL26.q50)	= 0v
.ic v(XARRAY_TOP.xCOL26.qb50)	= 0.7v
.ic v(XARRAY_TOP.xCOL27.q50)	= 0v
.ic v(XARRAY_TOP.xCOL27.qb50)	= 0.7v
.ic v(XARRAY_TOP.xCOL28.q50)	= 0v
.ic v(XARRAY_TOP.xCOL28.qb50)	= 0.7v
.ic v(XARRAY_TOP.xCOL29.q50)	= 0v
.ic v(XARRAY_TOP.xCOL29.qb50)	= 0.7v
.ic v(XARRAY_TOP.xCOL30.q50)	= 0v
.ic v(XARRAY_TOP.xCOL30.qb50)	= 0.7v
.ic v(XARRAY_TOP.xCOL31.q50)	= 0v
.ic v(XARRAY_TOP.xCOL31.qb50)	= 0.7v
.ic v(XARRAY_TOP.xCOL0.q51)	= 0v
.ic v(XARRAY_TOP.xCOL0.qb51)	= 0.7v
.ic v(XARRAY_TOP.xCOL1.q51)	= 0v
.ic v(XARRAY_TOP.xCOL1.qb51)	= 0.7v
.ic v(XARRAY_TOP.xCOL2.q51)	= 0v
.ic v(XARRAY_TOP.xCOL2.qb51)	= 0.7v
.ic v(XARRAY_TOP.xCOL3.q51)	= 0v
.ic v(XARRAY_TOP.xCOL3.qb51)	= 0.7v
.ic v(XARRAY_TOP.xCOL4.q51)	= 0v
.ic v(XARRAY_TOP.xCOL4.qb51)	= 0.7v
.ic v(XARRAY_TOP.xCOL5.q51)	= 0v
.ic v(XARRAY_TOP.xCOL5.qb51)	= 0.7v
.ic v(XARRAY_TOP.xCOL6.q51)	= 0v
.ic v(XARRAY_TOP.xCOL6.qb51)	= 0.7v
.ic v(XARRAY_TOP.xCOL7.q51)	= 0v
.ic v(XARRAY_TOP.xCOL7.qb51)	= 0.7v
.ic v(XARRAY_TOP.xCOL8.q51)	= 0v
.ic v(XARRAY_TOP.xCOL8.qb51)	= 0.7v
.ic v(XARRAY_TOP.xCOL9.q51)	= 0v
.ic v(XARRAY_TOP.xCOL9.qb51)	= 0.7v
.ic v(XARRAY_TOP.xCOL10.q51)	= 0v
.ic v(XARRAY_TOP.xCOL10.qb51)	= 0.7v
.ic v(XARRAY_TOP.xCOL11.q51)	= 0v
.ic v(XARRAY_TOP.xCOL11.qb51)	= 0.7v
.ic v(XARRAY_TOP.xCOL12.q51)	= 0v
.ic v(XARRAY_TOP.xCOL12.qb51)	= 0.7v
.ic v(XARRAY_TOP.xCOL13.q51)	= 0v
.ic v(XARRAY_TOP.xCOL13.qb51)	= 0.7v
.ic v(XARRAY_TOP.xCOL14.q51)	= 0v
.ic v(XARRAY_TOP.xCOL14.qb51)	= 0.7v
.ic v(XARRAY_TOP.xCOL15.q51)	= 0v
.ic v(XARRAY_TOP.xCOL15.qb51)	= 0.7v
.ic v(XARRAY_TOP.xCOL16.q51)	= 0v
.ic v(XARRAY_TOP.xCOL16.qb51)	= 0.7v
.ic v(XARRAY_TOP.xCOL17.q51)	= 0v
.ic v(XARRAY_TOP.xCOL17.qb51)	= 0.7v
.ic v(XARRAY_TOP.xCOL18.q51)	= 0v
.ic v(XARRAY_TOP.xCOL18.qb51)	= 0.7v
.ic v(XARRAY_TOP.xCOL19.q51)	= 0v
.ic v(XARRAY_TOP.xCOL19.qb51)	= 0.7v
.ic v(XARRAY_TOP.xCOL20.q51)	= 0v
.ic v(XARRAY_TOP.xCOL20.qb51)	= 0.7v
.ic v(XARRAY_TOP.xCOL21.q51)	= 0v
.ic v(XARRAY_TOP.xCOL21.qb51)	= 0.7v
.ic v(XARRAY_TOP.xCOL22.q51)	= 0v
.ic v(XARRAY_TOP.xCOL22.qb51)	= 0.7v
.ic v(XARRAY_TOP.xCOL23.q51)	= 0v
.ic v(XARRAY_TOP.xCOL23.qb51)	= 0.7v
.ic v(XARRAY_TOP.xCOL24.q51)	= 0v
.ic v(XARRAY_TOP.xCOL24.qb51)	= 0.7v
.ic v(XARRAY_TOP.xCOL25.q51)	= 0v
.ic v(XARRAY_TOP.xCOL25.qb51)	= 0.7v
.ic v(XARRAY_TOP.xCOL26.q51)	= 0v
.ic v(XARRAY_TOP.xCOL26.qb51)	= 0.7v
.ic v(XARRAY_TOP.xCOL27.q51)	= 0v
.ic v(XARRAY_TOP.xCOL27.qb51)	= 0.7v
.ic v(XARRAY_TOP.xCOL28.q51)	= 0v
.ic v(XARRAY_TOP.xCOL28.qb51)	= 0.7v
.ic v(XARRAY_TOP.xCOL29.q51)	= 0v
.ic v(XARRAY_TOP.xCOL29.qb51)	= 0.7v
.ic v(XARRAY_TOP.xCOL30.q51)	= 0v
.ic v(XARRAY_TOP.xCOL30.qb51)	= 0.7v
.ic v(XARRAY_TOP.xCOL31.q51)	= 0v
.ic v(XARRAY_TOP.xCOL31.qb51)	= 0.7v
.ic v(XARRAY_TOP.xCOL0.q52)	= 0v
.ic v(XARRAY_TOP.xCOL0.qb52)	= 0.7v
.ic v(XARRAY_TOP.xCOL1.q52)	= 0v
.ic v(XARRAY_TOP.xCOL1.qb52)	= 0.7v
.ic v(XARRAY_TOP.xCOL2.q52)	= 0v
.ic v(XARRAY_TOP.xCOL2.qb52)	= 0.7v
.ic v(XARRAY_TOP.xCOL3.q52)	= 0v
.ic v(XARRAY_TOP.xCOL3.qb52)	= 0.7v
.ic v(XARRAY_TOP.xCOL4.q52)	= 0v
.ic v(XARRAY_TOP.xCOL4.qb52)	= 0.7v
.ic v(XARRAY_TOP.xCOL5.q52)	= 0v
.ic v(XARRAY_TOP.xCOL5.qb52)	= 0.7v
.ic v(XARRAY_TOP.xCOL6.q52)	= 0v
.ic v(XARRAY_TOP.xCOL6.qb52)	= 0.7v
.ic v(XARRAY_TOP.xCOL7.q52)	= 0v
.ic v(XARRAY_TOP.xCOL7.qb52)	= 0.7v
.ic v(XARRAY_TOP.xCOL8.q52)	= 0v
.ic v(XARRAY_TOP.xCOL8.qb52)	= 0.7v
.ic v(XARRAY_TOP.xCOL9.q52)	= 0v
.ic v(XARRAY_TOP.xCOL9.qb52)	= 0.7v
.ic v(XARRAY_TOP.xCOL10.q52)	= 0v
.ic v(XARRAY_TOP.xCOL10.qb52)	= 0.7v
.ic v(XARRAY_TOP.xCOL11.q52)	= 0v
.ic v(XARRAY_TOP.xCOL11.qb52)	= 0.7v
.ic v(XARRAY_TOP.xCOL12.q52)	= 0v
.ic v(XARRAY_TOP.xCOL12.qb52)	= 0.7v
.ic v(XARRAY_TOP.xCOL13.q52)	= 0v
.ic v(XARRAY_TOP.xCOL13.qb52)	= 0.7v
.ic v(XARRAY_TOP.xCOL14.q52)	= 0v
.ic v(XARRAY_TOP.xCOL14.qb52)	= 0.7v
.ic v(XARRAY_TOP.xCOL15.q52)	= 0v
.ic v(XARRAY_TOP.xCOL15.qb52)	= 0.7v
.ic v(XARRAY_TOP.xCOL16.q52)	= 0v
.ic v(XARRAY_TOP.xCOL16.qb52)	= 0.7v
.ic v(XARRAY_TOP.xCOL17.q52)	= 0v
.ic v(XARRAY_TOP.xCOL17.qb52)	= 0.7v
.ic v(XARRAY_TOP.xCOL18.q52)	= 0v
.ic v(XARRAY_TOP.xCOL18.qb52)	= 0.7v
.ic v(XARRAY_TOP.xCOL19.q52)	= 0v
.ic v(XARRAY_TOP.xCOL19.qb52)	= 0.7v
.ic v(XARRAY_TOP.xCOL20.q52)	= 0v
.ic v(XARRAY_TOP.xCOL20.qb52)	= 0.7v
.ic v(XARRAY_TOP.xCOL21.q52)	= 0v
.ic v(XARRAY_TOP.xCOL21.qb52)	= 0.7v
.ic v(XARRAY_TOP.xCOL22.q52)	= 0v
.ic v(XARRAY_TOP.xCOL22.qb52)	= 0.7v
.ic v(XARRAY_TOP.xCOL23.q52)	= 0v
.ic v(XARRAY_TOP.xCOL23.qb52)	= 0.7v
.ic v(XARRAY_TOP.xCOL24.q52)	= 0v
.ic v(XARRAY_TOP.xCOL24.qb52)	= 0.7v
.ic v(XARRAY_TOP.xCOL25.q52)	= 0v
.ic v(XARRAY_TOP.xCOL25.qb52)	= 0.7v
.ic v(XARRAY_TOP.xCOL26.q52)	= 0v
.ic v(XARRAY_TOP.xCOL26.qb52)	= 0.7v
.ic v(XARRAY_TOP.xCOL27.q52)	= 0v
.ic v(XARRAY_TOP.xCOL27.qb52)	= 0.7v
.ic v(XARRAY_TOP.xCOL28.q52)	= 0v
.ic v(XARRAY_TOP.xCOL28.qb52)	= 0.7v
.ic v(XARRAY_TOP.xCOL29.q52)	= 0v
.ic v(XARRAY_TOP.xCOL29.qb52)	= 0.7v
.ic v(XARRAY_TOP.xCOL30.q52)	= 0v
.ic v(XARRAY_TOP.xCOL30.qb52)	= 0.7v
.ic v(XARRAY_TOP.xCOL31.q52)	= 0v
.ic v(XARRAY_TOP.xCOL31.qb52)	= 0.7v
.ic v(XARRAY_TOP.xCOL0.q53)	= 0v
.ic v(XARRAY_TOP.xCOL0.qb53)	= 0.7v
.ic v(XARRAY_TOP.xCOL1.q53)	= 0v
.ic v(XARRAY_TOP.xCOL1.qb53)	= 0.7v
.ic v(XARRAY_TOP.xCOL2.q53)	= 0v
.ic v(XARRAY_TOP.xCOL2.qb53)	= 0.7v
.ic v(XARRAY_TOP.xCOL3.q53)	= 0v
.ic v(XARRAY_TOP.xCOL3.qb53)	= 0.7v
.ic v(XARRAY_TOP.xCOL4.q53)	= 0v
.ic v(XARRAY_TOP.xCOL4.qb53)	= 0.7v
.ic v(XARRAY_TOP.xCOL5.q53)	= 0v
.ic v(XARRAY_TOP.xCOL5.qb53)	= 0.7v
.ic v(XARRAY_TOP.xCOL6.q53)	= 0v
.ic v(XARRAY_TOP.xCOL6.qb53)	= 0.7v
.ic v(XARRAY_TOP.xCOL7.q53)	= 0v
.ic v(XARRAY_TOP.xCOL7.qb53)	= 0.7v
.ic v(XARRAY_TOP.xCOL8.q53)	= 0v
.ic v(XARRAY_TOP.xCOL8.qb53)	= 0.7v
.ic v(XARRAY_TOP.xCOL9.q53)	= 0v
.ic v(XARRAY_TOP.xCOL9.qb53)	= 0.7v
.ic v(XARRAY_TOP.xCOL10.q53)	= 0v
.ic v(XARRAY_TOP.xCOL10.qb53)	= 0.7v
.ic v(XARRAY_TOP.xCOL11.q53)	= 0v
.ic v(XARRAY_TOP.xCOL11.qb53)	= 0.7v
.ic v(XARRAY_TOP.xCOL12.q53)	= 0v
.ic v(XARRAY_TOP.xCOL12.qb53)	= 0.7v
.ic v(XARRAY_TOP.xCOL13.q53)	= 0v
.ic v(XARRAY_TOP.xCOL13.qb53)	= 0.7v
.ic v(XARRAY_TOP.xCOL14.q53)	= 0v
.ic v(XARRAY_TOP.xCOL14.qb53)	= 0.7v
.ic v(XARRAY_TOP.xCOL15.q53)	= 0v
.ic v(XARRAY_TOP.xCOL15.qb53)	= 0.7v
.ic v(XARRAY_TOP.xCOL16.q53)	= 0v
.ic v(XARRAY_TOP.xCOL16.qb53)	= 0.7v
.ic v(XARRAY_TOP.xCOL17.q53)	= 0v
.ic v(XARRAY_TOP.xCOL17.qb53)	= 0.7v
.ic v(XARRAY_TOP.xCOL18.q53)	= 0v
.ic v(XARRAY_TOP.xCOL18.qb53)	= 0.7v
.ic v(XARRAY_TOP.xCOL19.q53)	= 0v
.ic v(XARRAY_TOP.xCOL19.qb53)	= 0.7v
.ic v(XARRAY_TOP.xCOL20.q53)	= 0v
.ic v(XARRAY_TOP.xCOL20.qb53)	= 0.7v
.ic v(XARRAY_TOP.xCOL21.q53)	= 0v
.ic v(XARRAY_TOP.xCOL21.qb53)	= 0.7v
.ic v(XARRAY_TOP.xCOL22.q53)	= 0v
.ic v(XARRAY_TOP.xCOL22.qb53)	= 0.7v
.ic v(XARRAY_TOP.xCOL23.q53)	= 0v
.ic v(XARRAY_TOP.xCOL23.qb53)	= 0.7v
.ic v(XARRAY_TOP.xCOL24.q53)	= 0v
.ic v(XARRAY_TOP.xCOL24.qb53)	= 0.7v
.ic v(XARRAY_TOP.xCOL25.q53)	= 0v
.ic v(XARRAY_TOP.xCOL25.qb53)	= 0.7v
.ic v(XARRAY_TOP.xCOL26.q53)	= 0v
.ic v(XARRAY_TOP.xCOL26.qb53)	= 0.7v
.ic v(XARRAY_TOP.xCOL27.q53)	= 0v
.ic v(XARRAY_TOP.xCOL27.qb53)	= 0.7v
.ic v(XARRAY_TOP.xCOL28.q53)	= 0v
.ic v(XARRAY_TOP.xCOL28.qb53)	= 0.7v
.ic v(XARRAY_TOP.xCOL29.q53)	= 0v
.ic v(XARRAY_TOP.xCOL29.qb53)	= 0.7v
.ic v(XARRAY_TOP.xCOL30.q53)	= 0v
.ic v(XARRAY_TOP.xCOL30.qb53)	= 0.7v
.ic v(XARRAY_TOP.xCOL31.q53)	= 0v
.ic v(XARRAY_TOP.xCOL31.qb53)	= 0.7v
.ic v(XARRAY_TOP.xCOL0.q54)	= 0v
.ic v(XARRAY_TOP.xCOL0.qb54)	= 0.7v
.ic v(XARRAY_TOP.xCOL1.q54)	= 0v
.ic v(XARRAY_TOP.xCOL1.qb54)	= 0.7v
.ic v(XARRAY_TOP.xCOL2.q54)	= 0v
.ic v(XARRAY_TOP.xCOL2.qb54)	= 0.7v
.ic v(XARRAY_TOP.xCOL3.q54)	= 0v
.ic v(XARRAY_TOP.xCOL3.qb54)	= 0.7v
.ic v(XARRAY_TOP.xCOL4.q54)	= 0v
.ic v(XARRAY_TOP.xCOL4.qb54)	= 0.7v
.ic v(XARRAY_TOP.xCOL5.q54)	= 0v
.ic v(XARRAY_TOP.xCOL5.qb54)	= 0.7v
.ic v(XARRAY_TOP.xCOL6.q54)	= 0v
.ic v(XARRAY_TOP.xCOL6.qb54)	= 0.7v
.ic v(XARRAY_TOP.xCOL7.q54)	= 0v
.ic v(XARRAY_TOP.xCOL7.qb54)	= 0.7v
.ic v(XARRAY_TOP.xCOL8.q54)	= 0v
.ic v(XARRAY_TOP.xCOL8.qb54)	= 0.7v
.ic v(XARRAY_TOP.xCOL9.q54)	= 0v
.ic v(XARRAY_TOP.xCOL9.qb54)	= 0.7v
.ic v(XARRAY_TOP.xCOL10.q54)	= 0v
.ic v(XARRAY_TOP.xCOL10.qb54)	= 0.7v
.ic v(XARRAY_TOP.xCOL11.q54)	= 0v
.ic v(XARRAY_TOP.xCOL11.qb54)	= 0.7v
.ic v(XARRAY_TOP.xCOL12.q54)	= 0v
.ic v(XARRAY_TOP.xCOL12.qb54)	= 0.7v
.ic v(XARRAY_TOP.xCOL13.q54)	= 0v
.ic v(XARRAY_TOP.xCOL13.qb54)	= 0.7v
.ic v(XARRAY_TOP.xCOL14.q54)	= 0v
.ic v(XARRAY_TOP.xCOL14.qb54)	= 0.7v
.ic v(XARRAY_TOP.xCOL15.q54)	= 0v
.ic v(XARRAY_TOP.xCOL15.qb54)	= 0.7v
.ic v(XARRAY_TOP.xCOL16.q54)	= 0v
.ic v(XARRAY_TOP.xCOL16.qb54)	= 0.7v
.ic v(XARRAY_TOP.xCOL17.q54)	= 0v
.ic v(XARRAY_TOP.xCOL17.qb54)	= 0.7v
.ic v(XARRAY_TOP.xCOL18.q54)	= 0v
.ic v(XARRAY_TOP.xCOL18.qb54)	= 0.7v
.ic v(XARRAY_TOP.xCOL19.q54)	= 0v
.ic v(XARRAY_TOP.xCOL19.qb54)	= 0.7v
.ic v(XARRAY_TOP.xCOL20.q54)	= 0v
.ic v(XARRAY_TOP.xCOL20.qb54)	= 0.7v
.ic v(XARRAY_TOP.xCOL21.q54)	= 0v
.ic v(XARRAY_TOP.xCOL21.qb54)	= 0.7v
.ic v(XARRAY_TOP.xCOL22.q54)	= 0v
.ic v(XARRAY_TOP.xCOL22.qb54)	= 0.7v
.ic v(XARRAY_TOP.xCOL23.q54)	= 0v
.ic v(XARRAY_TOP.xCOL23.qb54)	= 0.7v
.ic v(XARRAY_TOP.xCOL24.q54)	= 0v
.ic v(XARRAY_TOP.xCOL24.qb54)	= 0.7v
.ic v(XARRAY_TOP.xCOL25.q54)	= 0v
.ic v(XARRAY_TOP.xCOL25.qb54)	= 0.7v
.ic v(XARRAY_TOP.xCOL26.q54)	= 0v
.ic v(XARRAY_TOP.xCOL26.qb54)	= 0.7v
.ic v(XARRAY_TOP.xCOL27.q54)	= 0v
.ic v(XARRAY_TOP.xCOL27.qb54)	= 0.7v
.ic v(XARRAY_TOP.xCOL28.q54)	= 0v
.ic v(XARRAY_TOP.xCOL28.qb54)	= 0.7v
.ic v(XARRAY_TOP.xCOL29.q54)	= 0v
.ic v(XARRAY_TOP.xCOL29.qb54)	= 0.7v
.ic v(XARRAY_TOP.xCOL30.q54)	= 0v
.ic v(XARRAY_TOP.xCOL30.qb54)	= 0.7v
.ic v(XARRAY_TOP.xCOL31.q54)	= 0v
.ic v(XARRAY_TOP.xCOL31.qb54)	= 0.7v
.ic v(XARRAY_TOP.xCOL0.q55)	= 0v
.ic v(XARRAY_TOP.xCOL0.qb55)	= 0.7v
.ic v(XARRAY_TOP.xCOL1.q55)	= 0v
.ic v(XARRAY_TOP.xCOL1.qb55)	= 0.7v
.ic v(XARRAY_TOP.xCOL2.q55)	= 0v
.ic v(XARRAY_TOP.xCOL2.qb55)	= 0.7v
.ic v(XARRAY_TOP.xCOL3.q55)	= 0v
.ic v(XARRAY_TOP.xCOL3.qb55)	= 0.7v
.ic v(XARRAY_TOP.xCOL4.q55)	= 0v
.ic v(XARRAY_TOP.xCOL4.qb55)	= 0.7v
.ic v(XARRAY_TOP.xCOL5.q55)	= 0v
.ic v(XARRAY_TOP.xCOL5.qb55)	= 0.7v
.ic v(XARRAY_TOP.xCOL6.q55)	= 0v
.ic v(XARRAY_TOP.xCOL6.qb55)	= 0.7v
.ic v(XARRAY_TOP.xCOL7.q55)	= 0v
.ic v(XARRAY_TOP.xCOL7.qb55)	= 0.7v
.ic v(XARRAY_TOP.xCOL8.q55)	= 0v
.ic v(XARRAY_TOP.xCOL8.qb55)	= 0.7v
.ic v(XARRAY_TOP.xCOL9.q55)	= 0v
.ic v(XARRAY_TOP.xCOL9.qb55)	= 0.7v
.ic v(XARRAY_TOP.xCOL10.q55)	= 0v
.ic v(XARRAY_TOP.xCOL10.qb55)	= 0.7v
.ic v(XARRAY_TOP.xCOL11.q55)	= 0v
.ic v(XARRAY_TOP.xCOL11.qb55)	= 0.7v
.ic v(XARRAY_TOP.xCOL12.q55)	= 0v
.ic v(XARRAY_TOP.xCOL12.qb55)	= 0.7v
.ic v(XARRAY_TOP.xCOL13.q55)	= 0v
.ic v(XARRAY_TOP.xCOL13.qb55)	= 0.7v
.ic v(XARRAY_TOP.xCOL14.q55)	= 0v
.ic v(XARRAY_TOP.xCOL14.qb55)	= 0.7v
.ic v(XARRAY_TOP.xCOL15.q55)	= 0v
.ic v(XARRAY_TOP.xCOL15.qb55)	= 0.7v
.ic v(XARRAY_TOP.xCOL16.q55)	= 0v
.ic v(XARRAY_TOP.xCOL16.qb55)	= 0.7v
.ic v(XARRAY_TOP.xCOL17.q55)	= 0v
.ic v(XARRAY_TOP.xCOL17.qb55)	= 0.7v
.ic v(XARRAY_TOP.xCOL18.q55)	= 0v
.ic v(XARRAY_TOP.xCOL18.qb55)	= 0.7v
.ic v(XARRAY_TOP.xCOL19.q55)	= 0v
.ic v(XARRAY_TOP.xCOL19.qb55)	= 0.7v
.ic v(XARRAY_TOP.xCOL20.q55)	= 0v
.ic v(XARRAY_TOP.xCOL20.qb55)	= 0.7v
.ic v(XARRAY_TOP.xCOL21.q55)	= 0v
.ic v(XARRAY_TOP.xCOL21.qb55)	= 0.7v
.ic v(XARRAY_TOP.xCOL22.q55)	= 0v
.ic v(XARRAY_TOP.xCOL22.qb55)	= 0.7v
.ic v(XARRAY_TOP.xCOL23.q55)	= 0v
.ic v(XARRAY_TOP.xCOL23.qb55)	= 0.7v
.ic v(XARRAY_TOP.xCOL24.q55)	= 0v
.ic v(XARRAY_TOP.xCOL24.qb55)	= 0.7v
.ic v(XARRAY_TOP.xCOL25.q55)	= 0v
.ic v(XARRAY_TOP.xCOL25.qb55)	= 0.7v
.ic v(XARRAY_TOP.xCOL26.q55)	= 0v
.ic v(XARRAY_TOP.xCOL26.qb55)	= 0.7v
.ic v(XARRAY_TOP.xCOL27.q55)	= 0v
.ic v(XARRAY_TOP.xCOL27.qb55)	= 0.7v
.ic v(XARRAY_TOP.xCOL28.q55)	= 0v
.ic v(XARRAY_TOP.xCOL28.qb55)	= 0.7v
.ic v(XARRAY_TOP.xCOL29.q55)	= 0v
.ic v(XARRAY_TOP.xCOL29.qb55)	= 0.7v
.ic v(XARRAY_TOP.xCOL30.q55)	= 0v
.ic v(XARRAY_TOP.xCOL30.qb55)	= 0.7v
.ic v(XARRAY_TOP.xCOL31.q55)	= 0v
.ic v(XARRAY_TOP.xCOL31.qb55)	= 0.7v
.ic v(XARRAY_TOP.xCOL0.q56)	= 0v
.ic v(XARRAY_TOP.xCOL0.qb56)	= 0.7v
.ic v(XARRAY_TOP.xCOL1.q56)	= 0v
.ic v(XARRAY_TOP.xCOL1.qb56)	= 0.7v
.ic v(XARRAY_TOP.xCOL2.q56)	= 0v
.ic v(XARRAY_TOP.xCOL2.qb56)	= 0.7v
.ic v(XARRAY_TOP.xCOL3.q56)	= 0v
.ic v(XARRAY_TOP.xCOL3.qb56)	= 0.7v
.ic v(XARRAY_TOP.xCOL4.q56)	= 0v
.ic v(XARRAY_TOP.xCOL4.qb56)	= 0.7v
.ic v(XARRAY_TOP.xCOL5.q56)	= 0v
.ic v(XARRAY_TOP.xCOL5.qb56)	= 0.7v
.ic v(XARRAY_TOP.xCOL6.q56)	= 0v
.ic v(XARRAY_TOP.xCOL6.qb56)	= 0.7v
.ic v(XARRAY_TOP.xCOL7.q56)	= 0v
.ic v(XARRAY_TOP.xCOL7.qb56)	= 0.7v
.ic v(XARRAY_TOP.xCOL8.q56)	= 0v
.ic v(XARRAY_TOP.xCOL8.qb56)	= 0.7v
.ic v(XARRAY_TOP.xCOL9.q56)	= 0v
.ic v(XARRAY_TOP.xCOL9.qb56)	= 0.7v
.ic v(XARRAY_TOP.xCOL10.q56)	= 0v
.ic v(XARRAY_TOP.xCOL10.qb56)	= 0.7v
.ic v(XARRAY_TOP.xCOL11.q56)	= 0v
.ic v(XARRAY_TOP.xCOL11.qb56)	= 0.7v
.ic v(XARRAY_TOP.xCOL12.q56)	= 0v
.ic v(XARRAY_TOP.xCOL12.qb56)	= 0.7v
.ic v(XARRAY_TOP.xCOL13.q56)	= 0v
.ic v(XARRAY_TOP.xCOL13.qb56)	= 0.7v
.ic v(XARRAY_TOP.xCOL14.q56)	= 0v
.ic v(XARRAY_TOP.xCOL14.qb56)	= 0.7v
.ic v(XARRAY_TOP.xCOL15.q56)	= 0v
.ic v(XARRAY_TOP.xCOL15.qb56)	= 0.7v
.ic v(XARRAY_TOP.xCOL16.q56)	= 0v
.ic v(XARRAY_TOP.xCOL16.qb56)	= 0.7v
.ic v(XARRAY_TOP.xCOL17.q56)	= 0v
.ic v(XARRAY_TOP.xCOL17.qb56)	= 0.7v
.ic v(XARRAY_TOP.xCOL18.q56)	= 0v
.ic v(XARRAY_TOP.xCOL18.qb56)	= 0.7v
.ic v(XARRAY_TOP.xCOL19.q56)	= 0v
.ic v(XARRAY_TOP.xCOL19.qb56)	= 0.7v
.ic v(XARRAY_TOP.xCOL20.q56)	= 0v
.ic v(XARRAY_TOP.xCOL20.qb56)	= 0.7v
.ic v(XARRAY_TOP.xCOL21.q56)	= 0v
.ic v(XARRAY_TOP.xCOL21.qb56)	= 0.7v
.ic v(XARRAY_TOP.xCOL22.q56)	= 0v
.ic v(XARRAY_TOP.xCOL22.qb56)	= 0.7v
.ic v(XARRAY_TOP.xCOL23.q56)	= 0v
.ic v(XARRAY_TOP.xCOL23.qb56)	= 0.7v
.ic v(XARRAY_TOP.xCOL24.q56)	= 0v
.ic v(XARRAY_TOP.xCOL24.qb56)	= 0.7v
.ic v(XARRAY_TOP.xCOL25.q56)	= 0v
.ic v(XARRAY_TOP.xCOL25.qb56)	= 0.7v
.ic v(XARRAY_TOP.xCOL26.q56)	= 0v
.ic v(XARRAY_TOP.xCOL26.qb56)	= 0.7v
.ic v(XARRAY_TOP.xCOL27.q56)	= 0v
.ic v(XARRAY_TOP.xCOL27.qb56)	= 0.7v
.ic v(XARRAY_TOP.xCOL28.q56)	= 0v
.ic v(XARRAY_TOP.xCOL28.qb56)	= 0.7v
.ic v(XARRAY_TOP.xCOL29.q56)	= 0v
.ic v(XARRAY_TOP.xCOL29.qb56)	= 0.7v
.ic v(XARRAY_TOP.xCOL30.q56)	= 0v
.ic v(XARRAY_TOP.xCOL30.qb56)	= 0.7v
.ic v(XARRAY_TOP.xCOL31.q56)	= 0v
.ic v(XARRAY_TOP.xCOL31.qb56)	= 0.7v
.ic v(XARRAY_TOP.xCOL0.q57)	= 0v
.ic v(XARRAY_TOP.xCOL0.qb57)	= 0.7v
.ic v(XARRAY_TOP.xCOL1.q57)	= 0v
.ic v(XARRAY_TOP.xCOL1.qb57)	= 0.7v
.ic v(XARRAY_TOP.xCOL2.q57)	= 0v
.ic v(XARRAY_TOP.xCOL2.qb57)	= 0.7v
.ic v(XARRAY_TOP.xCOL3.q57)	= 0v
.ic v(XARRAY_TOP.xCOL3.qb57)	= 0.7v
.ic v(XARRAY_TOP.xCOL4.q57)	= 0v
.ic v(XARRAY_TOP.xCOL4.qb57)	= 0.7v
.ic v(XARRAY_TOP.xCOL5.q57)	= 0v
.ic v(XARRAY_TOP.xCOL5.qb57)	= 0.7v
.ic v(XARRAY_TOP.xCOL6.q57)	= 0v
.ic v(XARRAY_TOP.xCOL6.qb57)	= 0.7v
.ic v(XARRAY_TOP.xCOL7.q57)	= 0v
.ic v(XARRAY_TOP.xCOL7.qb57)	= 0.7v
.ic v(XARRAY_TOP.xCOL8.q57)	= 0v
.ic v(XARRAY_TOP.xCOL8.qb57)	= 0.7v
.ic v(XARRAY_TOP.xCOL9.q57)	= 0v
.ic v(XARRAY_TOP.xCOL9.qb57)	= 0.7v
.ic v(XARRAY_TOP.xCOL10.q57)	= 0v
.ic v(XARRAY_TOP.xCOL10.qb57)	= 0.7v
.ic v(XARRAY_TOP.xCOL11.q57)	= 0v
.ic v(XARRAY_TOP.xCOL11.qb57)	= 0.7v
.ic v(XARRAY_TOP.xCOL12.q57)	= 0v
.ic v(XARRAY_TOP.xCOL12.qb57)	= 0.7v
.ic v(XARRAY_TOP.xCOL13.q57)	= 0v
.ic v(XARRAY_TOP.xCOL13.qb57)	= 0.7v
.ic v(XARRAY_TOP.xCOL14.q57)	= 0v
.ic v(XARRAY_TOP.xCOL14.qb57)	= 0.7v
.ic v(XARRAY_TOP.xCOL15.q57)	= 0v
.ic v(XARRAY_TOP.xCOL15.qb57)	= 0.7v
.ic v(XARRAY_TOP.xCOL16.q57)	= 0v
.ic v(XARRAY_TOP.xCOL16.qb57)	= 0.7v
.ic v(XARRAY_TOP.xCOL17.q57)	= 0v
.ic v(XARRAY_TOP.xCOL17.qb57)	= 0.7v
.ic v(XARRAY_TOP.xCOL18.q57)	= 0v
.ic v(XARRAY_TOP.xCOL18.qb57)	= 0.7v
.ic v(XARRAY_TOP.xCOL19.q57)	= 0v
.ic v(XARRAY_TOP.xCOL19.qb57)	= 0.7v
.ic v(XARRAY_TOP.xCOL20.q57)	= 0v
.ic v(XARRAY_TOP.xCOL20.qb57)	= 0.7v
.ic v(XARRAY_TOP.xCOL21.q57)	= 0v
.ic v(XARRAY_TOP.xCOL21.qb57)	= 0.7v
.ic v(XARRAY_TOP.xCOL22.q57)	= 0v
.ic v(XARRAY_TOP.xCOL22.qb57)	= 0.7v
.ic v(XARRAY_TOP.xCOL23.q57)	= 0v
.ic v(XARRAY_TOP.xCOL23.qb57)	= 0.7v
.ic v(XARRAY_TOP.xCOL24.q57)	= 0v
.ic v(XARRAY_TOP.xCOL24.qb57)	= 0.7v
.ic v(XARRAY_TOP.xCOL25.q57)	= 0v
.ic v(XARRAY_TOP.xCOL25.qb57)	= 0.7v
.ic v(XARRAY_TOP.xCOL26.q57)	= 0v
.ic v(XARRAY_TOP.xCOL26.qb57)	= 0.7v
.ic v(XARRAY_TOP.xCOL27.q57)	= 0v
.ic v(XARRAY_TOP.xCOL27.qb57)	= 0.7v
.ic v(XARRAY_TOP.xCOL28.q57)	= 0v
.ic v(XARRAY_TOP.xCOL28.qb57)	= 0.7v
.ic v(XARRAY_TOP.xCOL29.q57)	= 0v
.ic v(XARRAY_TOP.xCOL29.qb57)	= 0.7v
.ic v(XARRAY_TOP.xCOL30.q57)	= 0v
.ic v(XARRAY_TOP.xCOL30.qb57)	= 0.7v
.ic v(XARRAY_TOP.xCOL31.q57)	= 0v
.ic v(XARRAY_TOP.xCOL31.qb57)	= 0.7v
.ic v(XARRAY_TOP.xCOL0.q58)	= 0v
.ic v(XARRAY_TOP.xCOL0.qb58)	= 0.7v
.ic v(XARRAY_TOP.xCOL1.q58)	= 0v
.ic v(XARRAY_TOP.xCOL1.qb58)	= 0.7v
.ic v(XARRAY_TOP.xCOL2.q58)	= 0v
.ic v(XARRAY_TOP.xCOL2.qb58)	= 0.7v
.ic v(XARRAY_TOP.xCOL3.q58)	= 0v
.ic v(XARRAY_TOP.xCOL3.qb58)	= 0.7v
.ic v(XARRAY_TOP.xCOL4.q58)	= 0v
.ic v(XARRAY_TOP.xCOL4.qb58)	= 0.7v
.ic v(XARRAY_TOP.xCOL5.q58)	= 0v
.ic v(XARRAY_TOP.xCOL5.qb58)	= 0.7v
.ic v(XARRAY_TOP.xCOL6.q58)	= 0v
.ic v(XARRAY_TOP.xCOL6.qb58)	= 0.7v
.ic v(XARRAY_TOP.xCOL7.q58)	= 0v
.ic v(XARRAY_TOP.xCOL7.qb58)	= 0.7v
.ic v(XARRAY_TOP.xCOL8.q58)	= 0v
.ic v(XARRAY_TOP.xCOL8.qb58)	= 0.7v
.ic v(XARRAY_TOP.xCOL9.q58)	= 0v
.ic v(XARRAY_TOP.xCOL9.qb58)	= 0.7v
.ic v(XARRAY_TOP.xCOL10.q58)	= 0v
.ic v(XARRAY_TOP.xCOL10.qb58)	= 0.7v
.ic v(XARRAY_TOP.xCOL11.q58)	= 0v
.ic v(XARRAY_TOP.xCOL11.qb58)	= 0.7v
.ic v(XARRAY_TOP.xCOL12.q58)	= 0v
.ic v(XARRAY_TOP.xCOL12.qb58)	= 0.7v
.ic v(XARRAY_TOP.xCOL13.q58)	= 0v
.ic v(XARRAY_TOP.xCOL13.qb58)	= 0.7v
.ic v(XARRAY_TOP.xCOL14.q58)	= 0v
.ic v(XARRAY_TOP.xCOL14.qb58)	= 0.7v
.ic v(XARRAY_TOP.xCOL15.q58)	= 0v
.ic v(XARRAY_TOP.xCOL15.qb58)	= 0.7v
.ic v(XARRAY_TOP.xCOL16.q58)	= 0v
.ic v(XARRAY_TOP.xCOL16.qb58)	= 0.7v
.ic v(XARRAY_TOP.xCOL17.q58)	= 0v
.ic v(XARRAY_TOP.xCOL17.qb58)	= 0.7v
.ic v(XARRAY_TOP.xCOL18.q58)	= 0v
.ic v(XARRAY_TOP.xCOL18.qb58)	= 0.7v
.ic v(XARRAY_TOP.xCOL19.q58)	= 0v
.ic v(XARRAY_TOP.xCOL19.qb58)	= 0.7v
.ic v(XARRAY_TOP.xCOL20.q58)	= 0v
.ic v(XARRAY_TOP.xCOL20.qb58)	= 0.7v
.ic v(XARRAY_TOP.xCOL21.q58)	= 0v
.ic v(XARRAY_TOP.xCOL21.qb58)	= 0.7v
.ic v(XARRAY_TOP.xCOL22.q58)	= 0v
.ic v(XARRAY_TOP.xCOL22.qb58)	= 0.7v
.ic v(XARRAY_TOP.xCOL23.q58)	= 0v
.ic v(XARRAY_TOP.xCOL23.qb58)	= 0.7v
.ic v(XARRAY_TOP.xCOL24.q58)	= 0v
.ic v(XARRAY_TOP.xCOL24.qb58)	= 0.7v
.ic v(XARRAY_TOP.xCOL25.q58)	= 0v
.ic v(XARRAY_TOP.xCOL25.qb58)	= 0.7v
.ic v(XARRAY_TOP.xCOL26.q58)	= 0v
.ic v(XARRAY_TOP.xCOL26.qb58)	= 0.7v
.ic v(XARRAY_TOP.xCOL27.q58)	= 0v
.ic v(XARRAY_TOP.xCOL27.qb58)	= 0.7v
.ic v(XARRAY_TOP.xCOL28.q58)	= 0v
.ic v(XARRAY_TOP.xCOL28.qb58)	= 0.7v
.ic v(XARRAY_TOP.xCOL29.q58)	= 0v
.ic v(XARRAY_TOP.xCOL29.qb58)	= 0.7v
.ic v(XARRAY_TOP.xCOL30.q58)	= 0v
.ic v(XARRAY_TOP.xCOL30.qb58)	= 0.7v
.ic v(XARRAY_TOP.xCOL31.q58)	= 0v
.ic v(XARRAY_TOP.xCOL31.qb58)	= 0.7v
.ic v(XARRAY_TOP.xCOL0.q59)	= 0v
.ic v(XARRAY_TOP.xCOL0.qb59)	= 0.7v
.ic v(XARRAY_TOP.xCOL1.q59)	= 0v
.ic v(XARRAY_TOP.xCOL1.qb59)	= 0.7v
.ic v(XARRAY_TOP.xCOL2.q59)	= 0v
.ic v(XARRAY_TOP.xCOL2.qb59)	= 0.7v
.ic v(XARRAY_TOP.xCOL3.q59)	= 0v
.ic v(XARRAY_TOP.xCOL3.qb59)	= 0.7v
.ic v(XARRAY_TOP.xCOL4.q59)	= 0v
.ic v(XARRAY_TOP.xCOL4.qb59)	= 0.7v
.ic v(XARRAY_TOP.xCOL5.q59)	= 0v
.ic v(XARRAY_TOP.xCOL5.qb59)	= 0.7v
.ic v(XARRAY_TOP.xCOL6.q59)	= 0v
.ic v(XARRAY_TOP.xCOL6.qb59)	= 0.7v
.ic v(XARRAY_TOP.xCOL7.q59)	= 0v
.ic v(XARRAY_TOP.xCOL7.qb59)	= 0.7v
.ic v(XARRAY_TOP.xCOL8.q59)	= 0v
.ic v(XARRAY_TOP.xCOL8.qb59)	= 0.7v
.ic v(XARRAY_TOP.xCOL9.q59)	= 0v
.ic v(XARRAY_TOP.xCOL9.qb59)	= 0.7v
.ic v(XARRAY_TOP.xCOL10.q59)	= 0v
.ic v(XARRAY_TOP.xCOL10.qb59)	= 0.7v
.ic v(XARRAY_TOP.xCOL11.q59)	= 0v
.ic v(XARRAY_TOP.xCOL11.qb59)	= 0.7v
.ic v(XARRAY_TOP.xCOL12.q59)	= 0v
.ic v(XARRAY_TOP.xCOL12.qb59)	= 0.7v
.ic v(XARRAY_TOP.xCOL13.q59)	= 0v
.ic v(XARRAY_TOP.xCOL13.qb59)	= 0.7v
.ic v(XARRAY_TOP.xCOL14.q59)	= 0v
.ic v(XARRAY_TOP.xCOL14.qb59)	= 0.7v
.ic v(XARRAY_TOP.xCOL15.q59)	= 0v
.ic v(XARRAY_TOP.xCOL15.qb59)	= 0.7v
.ic v(XARRAY_TOP.xCOL16.q59)	= 0v
.ic v(XARRAY_TOP.xCOL16.qb59)	= 0.7v
.ic v(XARRAY_TOP.xCOL17.q59)	= 0v
.ic v(XARRAY_TOP.xCOL17.qb59)	= 0.7v
.ic v(XARRAY_TOP.xCOL18.q59)	= 0v
.ic v(XARRAY_TOP.xCOL18.qb59)	= 0.7v
.ic v(XARRAY_TOP.xCOL19.q59)	= 0v
.ic v(XARRAY_TOP.xCOL19.qb59)	= 0.7v
.ic v(XARRAY_TOP.xCOL20.q59)	= 0v
.ic v(XARRAY_TOP.xCOL20.qb59)	= 0.7v
.ic v(XARRAY_TOP.xCOL21.q59)	= 0v
.ic v(XARRAY_TOP.xCOL21.qb59)	= 0.7v
.ic v(XARRAY_TOP.xCOL22.q59)	= 0v
.ic v(XARRAY_TOP.xCOL22.qb59)	= 0.7v
.ic v(XARRAY_TOP.xCOL23.q59)	= 0v
.ic v(XARRAY_TOP.xCOL23.qb59)	= 0.7v
.ic v(XARRAY_TOP.xCOL24.q59)	= 0v
.ic v(XARRAY_TOP.xCOL24.qb59)	= 0.7v
.ic v(XARRAY_TOP.xCOL25.q59)	= 0v
.ic v(XARRAY_TOP.xCOL25.qb59)	= 0.7v
.ic v(XARRAY_TOP.xCOL26.q59)	= 0v
.ic v(XARRAY_TOP.xCOL26.qb59)	= 0.7v
.ic v(XARRAY_TOP.xCOL27.q59)	= 0v
.ic v(XARRAY_TOP.xCOL27.qb59)	= 0.7v
.ic v(XARRAY_TOP.xCOL28.q59)	= 0v
.ic v(XARRAY_TOP.xCOL28.qb59)	= 0.7v
.ic v(XARRAY_TOP.xCOL29.q59)	= 0v
.ic v(XARRAY_TOP.xCOL29.qb59)	= 0.7v
.ic v(XARRAY_TOP.xCOL30.q59)	= 0v
.ic v(XARRAY_TOP.xCOL30.qb59)	= 0.7v
.ic v(XARRAY_TOP.xCOL31.q59)	= 0v
.ic v(XARRAY_TOP.xCOL31.qb59)	= 0.7v
.ic v(XARRAY_TOP.xCOL0.q60)	= 0v
.ic v(XARRAY_TOP.xCOL0.qb60)	= 0.7v
.ic v(XARRAY_TOP.xCOL1.q60)	= 0v
.ic v(XARRAY_TOP.xCOL1.qb60)	= 0.7v
.ic v(XARRAY_TOP.xCOL2.q60)	= 0v
.ic v(XARRAY_TOP.xCOL2.qb60)	= 0.7v
.ic v(XARRAY_TOP.xCOL3.q60)	= 0v
.ic v(XARRAY_TOP.xCOL3.qb60)	= 0.7v
.ic v(XARRAY_TOP.xCOL4.q60)	= 0v
.ic v(XARRAY_TOP.xCOL4.qb60)	= 0.7v
.ic v(XARRAY_TOP.xCOL5.q60)	= 0v
.ic v(XARRAY_TOP.xCOL5.qb60)	= 0.7v
.ic v(XARRAY_TOP.xCOL6.q60)	= 0v
.ic v(XARRAY_TOP.xCOL6.qb60)	= 0.7v
.ic v(XARRAY_TOP.xCOL7.q60)	= 0v
.ic v(XARRAY_TOP.xCOL7.qb60)	= 0.7v
.ic v(XARRAY_TOP.xCOL8.q60)	= 0v
.ic v(XARRAY_TOP.xCOL8.qb60)	= 0.7v
.ic v(XARRAY_TOP.xCOL9.q60)	= 0v
.ic v(XARRAY_TOP.xCOL9.qb60)	= 0.7v
.ic v(XARRAY_TOP.xCOL10.q60)	= 0v
.ic v(XARRAY_TOP.xCOL10.qb60)	= 0.7v
.ic v(XARRAY_TOP.xCOL11.q60)	= 0v
.ic v(XARRAY_TOP.xCOL11.qb60)	= 0.7v
.ic v(XARRAY_TOP.xCOL12.q60)	= 0v
.ic v(XARRAY_TOP.xCOL12.qb60)	= 0.7v
.ic v(XARRAY_TOP.xCOL13.q60)	= 0v
.ic v(XARRAY_TOP.xCOL13.qb60)	= 0.7v
.ic v(XARRAY_TOP.xCOL14.q60)	= 0v
.ic v(XARRAY_TOP.xCOL14.qb60)	= 0.7v
.ic v(XARRAY_TOP.xCOL15.q60)	= 0v
.ic v(XARRAY_TOP.xCOL15.qb60)	= 0.7v
.ic v(XARRAY_TOP.xCOL16.q60)	= 0v
.ic v(XARRAY_TOP.xCOL16.qb60)	= 0.7v
.ic v(XARRAY_TOP.xCOL17.q60)	= 0v
.ic v(XARRAY_TOP.xCOL17.qb60)	= 0.7v
.ic v(XARRAY_TOP.xCOL18.q60)	= 0v
.ic v(XARRAY_TOP.xCOL18.qb60)	= 0.7v
.ic v(XARRAY_TOP.xCOL19.q60)	= 0v
.ic v(XARRAY_TOP.xCOL19.qb60)	= 0.7v
.ic v(XARRAY_TOP.xCOL20.q60)	= 0v
.ic v(XARRAY_TOP.xCOL20.qb60)	= 0.7v
.ic v(XARRAY_TOP.xCOL21.q60)	= 0v
.ic v(XARRAY_TOP.xCOL21.qb60)	= 0.7v
.ic v(XARRAY_TOP.xCOL22.q60)	= 0v
.ic v(XARRAY_TOP.xCOL22.qb60)	= 0.7v
.ic v(XARRAY_TOP.xCOL23.q60)	= 0v
.ic v(XARRAY_TOP.xCOL23.qb60)	= 0.7v
.ic v(XARRAY_TOP.xCOL24.q60)	= 0v
.ic v(XARRAY_TOP.xCOL24.qb60)	= 0.7v
.ic v(XARRAY_TOP.xCOL25.q60)	= 0v
.ic v(XARRAY_TOP.xCOL25.qb60)	= 0.7v
.ic v(XARRAY_TOP.xCOL26.q60)	= 0v
.ic v(XARRAY_TOP.xCOL26.qb60)	= 0.7v
.ic v(XARRAY_TOP.xCOL27.q60)	= 0v
.ic v(XARRAY_TOP.xCOL27.qb60)	= 0.7v
.ic v(XARRAY_TOP.xCOL28.q60)	= 0v
.ic v(XARRAY_TOP.xCOL28.qb60)	= 0.7v
.ic v(XARRAY_TOP.xCOL29.q60)	= 0v
.ic v(XARRAY_TOP.xCOL29.qb60)	= 0.7v
.ic v(XARRAY_TOP.xCOL30.q60)	= 0v
.ic v(XARRAY_TOP.xCOL30.qb60)	= 0.7v
.ic v(XARRAY_TOP.xCOL31.q60)	= 0v
.ic v(XARRAY_TOP.xCOL31.qb60)	= 0.7v
.ic v(XARRAY_TOP.xCOL0.q61)	= 0v
.ic v(XARRAY_TOP.xCOL0.qb61)	= 0.7v
.ic v(XARRAY_TOP.xCOL1.q61)	= 0v
.ic v(XARRAY_TOP.xCOL1.qb61)	= 0.7v
.ic v(XARRAY_TOP.xCOL2.q61)	= 0v
.ic v(XARRAY_TOP.xCOL2.qb61)	= 0.7v
.ic v(XARRAY_TOP.xCOL3.q61)	= 0v
.ic v(XARRAY_TOP.xCOL3.qb61)	= 0.7v
.ic v(XARRAY_TOP.xCOL4.q61)	= 0v
.ic v(XARRAY_TOP.xCOL4.qb61)	= 0.7v
.ic v(XARRAY_TOP.xCOL5.q61)	= 0v
.ic v(XARRAY_TOP.xCOL5.qb61)	= 0.7v
.ic v(XARRAY_TOP.xCOL6.q61)	= 0v
.ic v(XARRAY_TOP.xCOL6.qb61)	= 0.7v
.ic v(XARRAY_TOP.xCOL7.q61)	= 0v
.ic v(XARRAY_TOP.xCOL7.qb61)	= 0.7v
.ic v(XARRAY_TOP.xCOL8.q61)	= 0v
.ic v(XARRAY_TOP.xCOL8.qb61)	= 0.7v
.ic v(XARRAY_TOP.xCOL9.q61)	= 0v
.ic v(XARRAY_TOP.xCOL9.qb61)	= 0.7v
.ic v(XARRAY_TOP.xCOL10.q61)	= 0v
.ic v(XARRAY_TOP.xCOL10.qb61)	= 0.7v
.ic v(XARRAY_TOP.xCOL11.q61)	= 0v
.ic v(XARRAY_TOP.xCOL11.qb61)	= 0.7v
.ic v(XARRAY_TOP.xCOL12.q61)	= 0v
.ic v(XARRAY_TOP.xCOL12.qb61)	= 0.7v
.ic v(XARRAY_TOP.xCOL13.q61)	= 0v
.ic v(XARRAY_TOP.xCOL13.qb61)	= 0.7v
.ic v(XARRAY_TOP.xCOL14.q61)	= 0v
.ic v(XARRAY_TOP.xCOL14.qb61)	= 0.7v
.ic v(XARRAY_TOP.xCOL15.q61)	= 0v
.ic v(XARRAY_TOP.xCOL15.qb61)	= 0.7v
.ic v(XARRAY_TOP.xCOL16.q61)	= 0v
.ic v(XARRAY_TOP.xCOL16.qb61)	= 0.7v
.ic v(XARRAY_TOP.xCOL17.q61)	= 0v
.ic v(XARRAY_TOP.xCOL17.qb61)	= 0.7v
.ic v(XARRAY_TOP.xCOL18.q61)	= 0v
.ic v(XARRAY_TOP.xCOL18.qb61)	= 0.7v
.ic v(XARRAY_TOP.xCOL19.q61)	= 0v
.ic v(XARRAY_TOP.xCOL19.qb61)	= 0.7v
.ic v(XARRAY_TOP.xCOL20.q61)	= 0v
.ic v(XARRAY_TOP.xCOL20.qb61)	= 0.7v
.ic v(XARRAY_TOP.xCOL21.q61)	= 0v
.ic v(XARRAY_TOP.xCOL21.qb61)	= 0.7v
.ic v(XARRAY_TOP.xCOL22.q61)	= 0v
.ic v(XARRAY_TOP.xCOL22.qb61)	= 0.7v
.ic v(XARRAY_TOP.xCOL23.q61)	= 0v
.ic v(XARRAY_TOP.xCOL23.qb61)	= 0.7v
.ic v(XARRAY_TOP.xCOL24.q61)	= 0v
.ic v(XARRAY_TOP.xCOL24.qb61)	= 0.7v
.ic v(XARRAY_TOP.xCOL25.q61)	= 0v
.ic v(XARRAY_TOP.xCOL25.qb61)	= 0.7v
.ic v(XARRAY_TOP.xCOL26.q61)	= 0v
.ic v(XARRAY_TOP.xCOL26.qb61)	= 0.7v
.ic v(XARRAY_TOP.xCOL27.q61)	= 0v
.ic v(XARRAY_TOP.xCOL27.qb61)	= 0.7v
.ic v(XARRAY_TOP.xCOL28.q61)	= 0v
.ic v(XARRAY_TOP.xCOL28.qb61)	= 0.7v
.ic v(XARRAY_TOP.xCOL29.q61)	= 0v
.ic v(XARRAY_TOP.xCOL29.qb61)	= 0.7v
.ic v(XARRAY_TOP.xCOL30.q61)	= 0v
.ic v(XARRAY_TOP.xCOL30.qb61)	= 0.7v
.ic v(XARRAY_TOP.xCOL31.q61)	= 0v
.ic v(XARRAY_TOP.xCOL31.qb61)	= 0.7v
.ic v(XARRAY_TOP.xCOL0.q62)	= 0v
.ic v(XARRAY_TOP.xCOL0.qb62)	= 0.7v
.ic v(XARRAY_TOP.xCOL1.q62)	= 0v
.ic v(XARRAY_TOP.xCOL1.qb62)	= 0.7v
.ic v(XARRAY_TOP.xCOL2.q62)	= 0v
.ic v(XARRAY_TOP.xCOL2.qb62)	= 0.7v
.ic v(XARRAY_TOP.xCOL3.q62)	= 0v
.ic v(XARRAY_TOP.xCOL3.qb62)	= 0.7v
.ic v(XARRAY_TOP.xCOL4.q62)	= 0v
.ic v(XARRAY_TOP.xCOL4.qb62)	= 0.7v
.ic v(XARRAY_TOP.xCOL5.q62)	= 0v
.ic v(XARRAY_TOP.xCOL5.qb62)	= 0.7v
.ic v(XARRAY_TOP.xCOL6.q62)	= 0v
.ic v(XARRAY_TOP.xCOL6.qb62)	= 0.7v
.ic v(XARRAY_TOP.xCOL7.q62)	= 0v
.ic v(XARRAY_TOP.xCOL7.qb62)	= 0.7v
.ic v(XARRAY_TOP.xCOL8.q62)	= 0v
.ic v(XARRAY_TOP.xCOL8.qb62)	= 0.7v
.ic v(XARRAY_TOP.xCOL9.q62)	= 0v
.ic v(XARRAY_TOP.xCOL9.qb62)	= 0.7v
.ic v(XARRAY_TOP.xCOL10.q62)	= 0v
.ic v(XARRAY_TOP.xCOL10.qb62)	= 0.7v
.ic v(XARRAY_TOP.xCOL11.q62)	= 0v
.ic v(XARRAY_TOP.xCOL11.qb62)	= 0.7v
.ic v(XARRAY_TOP.xCOL12.q62)	= 0v
.ic v(XARRAY_TOP.xCOL12.qb62)	= 0.7v
.ic v(XARRAY_TOP.xCOL13.q62)	= 0v
.ic v(XARRAY_TOP.xCOL13.qb62)	= 0.7v
.ic v(XARRAY_TOP.xCOL14.q62)	= 0v
.ic v(XARRAY_TOP.xCOL14.qb62)	= 0.7v
.ic v(XARRAY_TOP.xCOL15.q62)	= 0v
.ic v(XARRAY_TOP.xCOL15.qb62)	= 0.7v
.ic v(XARRAY_TOP.xCOL16.q62)	= 0v
.ic v(XARRAY_TOP.xCOL16.qb62)	= 0.7v
.ic v(XARRAY_TOP.xCOL17.q62)	= 0v
.ic v(XARRAY_TOP.xCOL17.qb62)	= 0.7v
.ic v(XARRAY_TOP.xCOL18.q62)	= 0v
.ic v(XARRAY_TOP.xCOL18.qb62)	= 0.7v
.ic v(XARRAY_TOP.xCOL19.q62)	= 0v
.ic v(XARRAY_TOP.xCOL19.qb62)	= 0.7v
.ic v(XARRAY_TOP.xCOL20.q62)	= 0v
.ic v(XARRAY_TOP.xCOL20.qb62)	= 0.7v
.ic v(XARRAY_TOP.xCOL21.q62)	= 0v
.ic v(XARRAY_TOP.xCOL21.qb62)	= 0.7v
.ic v(XARRAY_TOP.xCOL22.q62)	= 0v
.ic v(XARRAY_TOP.xCOL22.qb62)	= 0.7v
.ic v(XARRAY_TOP.xCOL23.q62)	= 0v
.ic v(XARRAY_TOP.xCOL23.qb62)	= 0.7v
.ic v(XARRAY_TOP.xCOL24.q62)	= 0v
.ic v(XARRAY_TOP.xCOL24.qb62)	= 0.7v
.ic v(XARRAY_TOP.xCOL25.q62)	= 0v
.ic v(XARRAY_TOP.xCOL25.qb62)	= 0.7v
.ic v(XARRAY_TOP.xCOL26.q62)	= 0v
.ic v(XARRAY_TOP.xCOL26.qb62)	= 0.7v
.ic v(XARRAY_TOP.xCOL27.q62)	= 0v
.ic v(XARRAY_TOP.xCOL27.qb62)	= 0.7v
.ic v(XARRAY_TOP.xCOL28.q62)	= 0v
.ic v(XARRAY_TOP.xCOL28.qb62)	= 0.7v
.ic v(XARRAY_TOP.xCOL29.q62)	= 0v
.ic v(XARRAY_TOP.xCOL29.qb62)	= 0.7v
.ic v(XARRAY_TOP.xCOL30.q62)	= 0v
.ic v(XARRAY_TOP.xCOL30.qb62)	= 0.7v
.ic v(XARRAY_TOP.xCOL31.q62)	= 0v
.ic v(XARRAY_TOP.xCOL31.qb62)	= 0.7v
.ic v(XARRAY_TOP.xCOL0.q63)	= 0v
.ic v(XARRAY_TOP.xCOL0.qb63)	= 0.7v
.ic v(XARRAY_TOP.xCOL1.q63)	= 0v
.ic v(XARRAY_TOP.xCOL1.qb63)	= 0.7v
.ic v(XARRAY_TOP.xCOL2.q63)	= 0v
.ic v(XARRAY_TOP.xCOL2.qb63)	= 0.7v
.ic v(XARRAY_TOP.xCOL3.q63)	= 0v
.ic v(XARRAY_TOP.xCOL3.qb63)	= 0.7v
.ic v(XARRAY_TOP.xCOL4.q63)	= 0v
.ic v(XARRAY_TOP.xCOL4.qb63)	= 0.7v
.ic v(XARRAY_TOP.xCOL5.q63)	= 0v
.ic v(XARRAY_TOP.xCOL5.qb63)	= 0.7v
.ic v(XARRAY_TOP.xCOL6.q63)	= 0v
.ic v(XARRAY_TOP.xCOL6.qb63)	= 0.7v
.ic v(XARRAY_TOP.xCOL7.q63)	= 0v
.ic v(XARRAY_TOP.xCOL7.qb63)	= 0.7v
.ic v(XARRAY_TOP.xCOL8.q63)	= 0v
.ic v(XARRAY_TOP.xCOL8.qb63)	= 0.7v
.ic v(XARRAY_TOP.xCOL9.q63)	= 0v
.ic v(XARRAY_TOP.xCOL9.qb63)	= 0.7v
.ic v(XARRAY_TOP.xCOL10.q63)	= 0v
.ic v(XARRAY_TOP.xCOL10.qb63)	= 0.7v
.ic v(XARRAY_TOP.xCOL11.q63)	= 0v
.ic v(XARRAY_TOP.xCOL11.qb63)	= 0.7v
.ic v(XARRAY_TOP.xCOL12.q63)	= 0v
.ic v(XARRAY_TOP.xCOL12.qb63)	= 0.7v
.ic v(XARRAY_TOP.xCOL13.q63)	= 0v
.ic v(XARRAY_TOP.xCOL13.qb63)	= 0.7v
.ic v(XARRAY_TOP.xCOL14.q63)	= 0v
.ic v(XARRAY_TOP.xCOL14.qb63)	= 0.7v
.ic v(XARRAY_TOP.xCOL15.q63)	= 0v
.ic v(XARRAY_TOP.xCOL15.qb63)	= 0.7v
.ic v(XARRAY_TOP.xCOL16.q63)	= 0v
.ic v(XARRAY_TOP.xCOL16.qb63)	= 0.7v
.ic v(XARRAY_TOP.xCOL17.q63)	= 0v
.ic v(XARRAY_TOP.xCOL17.qb63)	= 0.7v
.ic v(XARRAY_TOP.xCOL18.q63)	= 0v
.ic v(XARRAY_TOP.xCOL18.qb63)	= 0.7v
.ic v(XARRAY_TOP.xCOL19.q63)	= 0v
.ic v(XARRAY_TOP.xCOL19.qb63)	= 0.7v
.ic v(XARRAY_TOP.xCOL20.q63)	= 0v
.ic v(XARRAY_TOP.xCOL20.qb63)	= 0.7v
.ic v(XARRAY_TOP.xCOL21.q63)	= 0v
.ic v(XARRAY_TOP.xCOL21.qb63)	= 0.7v
.ic v(XARRAY_TOP.xCOL22.q63)	= 0v
.ic v(XARRAY_TOP.xCOL22.qb63)	= 0.7v
.ic v(XARRAY_TOP.xCOL23.q63)	= 0v
.ic v(XARRAY_TOP.xCOL23.qb63)	= 0.7v
.ic v(XARRAY_TOP.xCOL24.q63)	= 0v
.ic v(XARRAY_TOP.xCOL24.qb63)	= 0.7v
.ic v(XARRAY_TOP.xCOL25.q63)	= 0v
.ic v(XARRAY_TOP.xCOL25.qb63)	= 0.7v
.ic v(XARRAY_TOP.xCOL26.q63)	= 0v
.ic v(XARRAY_TOP.xCOL26.qb63)	= 0.7v
.ic v(XARRAY_TOP.xCOL27.q63)	= 0v
.ic v(XARRAY_TOP.xCOL27.qb63)	= 0.7v
.ic v(XARRAY_TOP.xCOL28.q63)	= 0v
.ic v(XARRAY_TOP.xCOL28.qb63)	= 0.7v
.ic v(XARRAY_TOP.xCOL29.q63)	= 0v
.ic v(XARRAY_TOP.xCOL29.qb63)	= 0.7v
.ic v(XARRAY_TOP.xCOL30.q63)	= 0v
.ic v(XARRAY_TOP.xCOL30.qb63)	= 0.7v
.ic v(XARRAY_TOP.xCOL31.q63)	= 0v
.ic v(XARRAY_TOP.xCOL31.qb63)	= 0.7v

*****************************
**    Simulator setting    **
*****************************
.op
.option post
.options probe
*.probe v(*) i(*)

.probe tran v(A0) v(A1) v(A2) v(A3) v(A4) v(A5) v(A6)
.probe tran v(D0) v(D1) v(D2) v(D3) v(D4) v(D5) v(D6) v(D7) v(D8) v(D9) v(D10) v(D11) v(D12) v(D13) v(D14) v(D15)
.probe tran v(Q0) v(Q1) v(Q2) v(Q3) v(Q4) v(Q5) v(Q6) v(Q7) v(Q8) v(Q9) v(Q10) v(Q11) v(Q12) v(Q13) v(Q14) v(Q15)
.probe tran v(QB0) v(QB1) v(QB2) v(QB3) v(QB4) v(QB5) v(QB6) v(QB7) v(QB8) v(QB9) v(QB10) v(QB11) v(QB12) v(QB13) v(QB14) v(QB15)
.probe tran v(A0q) v(A1q) v(A2q) v(A3q) v(A4q) v(A5q) v(A6q)
.probe tran v(D0q) v(D1q) v(D2q) v(D3q) v(D4q) v(D5q) v(D6q) v(D7q) v(D8q) v(D9q) v(D10q) v(D11q) v(D12q) v(D13q) v(D14q) v(D15q)
.probe tran v(CLK) v(PRE) v(SAEN) v(WEN) v(WENq)
.tran 0.05ns 20ns
