********************************************************************
** 64x32 SRAM Array Subcircuit Definition                          **
********************************************************************
* 因為這個大陣列裡面需要用到 64x1 的積木，所以要先把它拉進來
.include 'SRAM_column_64x1.sp'

.subckt SRAM_Array_64x32
+ PRE SAEN VDD GND
* --- 以下是 64 條共享的 Wordlines ---
+ WL0  WL1  WL2  WL3  WL4  WL5  WL6  WL7  WL8  WL9  WL10 WL11 WL12 WL13 WL14 WL15
+ WL16 WL17 WL18 WL19 WL20 WL21 WL22 WL23 WL24 WL25 WL26 WL27 WL28 WL29 WL30 WL31
+ WL32 WL33 WL34 WL35 WL36 WL37 WL38 WL39 WL40 WL41 WL42 WL43 WL44 WL45 WL46 WL47
+ WL48 WL49 WL50 WL51 WL52 WL53 WL54 WL55 WL56 WL57 WL58 WL59 WL60 WL61 WL62 WL63

* --- 以下是 32 組獨立的控制與輸出線 (以 Column 0 ~ 31 命名) ---
* Column 0
+ SENSE_OUT0 SENSE_OUTB0 WEN_BL0 WEN_BLB0
* Column 1
+ SENSE_OUT1 SENSE_OUTB1  WEN_BL1  WEN_BLB1
* Column 2
+ SENSE_OUT2 SENSE_OUTB2  WEN_BL2  WEN_BLB2
* Column 3
+ SENSE_OUT3 SENSE_OUTB3  WEN_BL3  WEN_BLB3
* Column 4
+ SENSE_OUT4 SENSE_OUTB4  WEN_BL4  WEN_BLB4
* Column 5
+ SENSE_OUT5 SENSE_OUTB5  WEN_BL5  WEN_BLB5
* Column 6
+ SENSE_OUT6 SENSE_OUTB6  WEN_BL6  WEN_BLB6
* Column 7
+ SENSE_OUT7 SENSE_OUTB7  WEN_BL7  WEN_BLB7
* Column 8
+ SENSE_OUT8 SENSE_OUTB8  WEN_BL8  WEN_BLB8
* Column 9
+ SENSE_OUT9 SENSE_OUTB9  WEN_BL9  WEN_BLB9
* Column 10
+ SENSE_OUT10 SENSE_OUTB10 WEN_BL10 WEN_BLB10
* Column 11
+ SENSE_OUT11 SENSE_OUTB11 WEN_BL11 WEN_BLB11
* Column 12
+ SENSE_OUT12 SENSE_OUTB12 WEN_BL12 WEN_BLB12
* Column 13
+ SENSE_OUT13 SENSE_OUTB13 WEN_BL13 WEN_BLB13
* Column 14
+ SENSE_OUT14 SENSE_OUTB14 WEN_BL14 WEN_BLB14
* Column 15
+ SENSE_OUT15 SENSE_OUTB15 WEN_BL15 WEN_BLB15
* Column 16
+ SENSE_OUT16 SENSE_OUTB16 WEN_BL16 WEN_BLB16
* Column 17
+ SENSE_OUT17 SENSE_OUTB17 WEN_BL17 WEN_BLB17
* Column 18
+ SENSE_OUT18 SENSE_OUTB18 WEN_BL18 WEN_BLB18
* Column 19
+ SENSE_OUT19 SENSE_OUTB19 WEN_BL19 WEN_BLB19
* Column 20
+ SENSE_OUT20 SENSE_OUTB20 WEN_BL20 WEN_BLB20
* Column 21
+ SENSE_OUT21 SENSE_OUTB21 WEN_BL21 WEN_BLB21
* Column 22
+ SENSE_OUT22 SENSE_OUTB22 WEN_BL22 WEN_BLB22
* Column 23
+ SENSE_OUT23 SENSE_OUTB23 WEN_BL23 WEN_BLB23
* Column 24
+ SENSE_OUT24 SENSE_OUTB24 WEN_BL24 WEN_BLB24
* Column 25
+ SENSE_OUT25 SENSE_OUTB25 WEN_BL25 WEN_BLB25
* Column 26
+ SENSE_OUT26 SENSE_OUTB26 WEN_BL26 WEN_BLB26
* Column 27
+ SENSE_OUT27 SENSE_OUTB27 WEN_BL27 WEN_BLB27
* Column 28
+ SENSE_OUT28 SENSE_OUTB28 WEN_BL28 WEN_BLB28
* Column 29
+ SENSE_OUT29 SENSE_OUTB29 WEN_BL29 WEN_BLB29
* Column 30
+ SENSE_OUT30 SENSE_OUTB30 WEN_BL30 WEN_BLB30
* Column 31
+ SENSE_OUT31 SENSE_OUTB31 WEN_BL31 WEN_BLB31

********************************************************************
** 子電路內部：平行呼叫 32 個 64x1 Column                           **
********************************************************************
* 注意：這裡傳入的引腳順序，必須完全符合你原始 SRAM_Column_64x1 的定義

xCOL0
+ PRE SAEN SENSE_OUT0 SENSE_OUTB0 WEN_BL0 WEN_BLB0 VDD GND
+ WL0 WL1 WL2 WL3 WL4 WL5 WL6 WL7 WL8 WL9 WL10 WL11 WL12 WL13 WL14 WL15
+ WL16 WL17 WL18 WL19 WL20 WL21 WL22 WL23 WL24 WL25 WL26 WL27 WL28 WL29 WL30 WL31
+ WL32 WL33 WL34 WL35 WL36 WL37 WL38 WL39 WL40 WL41 WL42 WL43 WL44 WL45 WL46 WL47
+ WL48 WL49 WL50 WL51 WL52 WL53 WL54 WL55 WL56 WL57 WL58 WL59 WL60 WL61 WL62 WL63
+ SRAM_Column_64x1

xCOL1
+ PRE SAEN SENSE_OUT1 SENSE_OUTB1 WEN_BL1 WEN_BLB1 VDD GND
+ WL0 WL1 WL2 WL3 WL4 WL5 WL6 WL7 WL8 WL9 WL10 WL11 WL12 WL13 WL14 WL15
+ WL16 WL17 WL18 WL19 WL20 WL21 WL22 WL23 WL24 WL25 WL26 WL27 WL28 WL29 WL30 WL31
+ WL32 WL33 WL34 WL35 WL36 WL37 WL38 WL39 WL40 WL41 WL42 WL43 WL44 WL45 WL46 WL47
+ WL48 WL49 WL50 WL51 WL52 WL53 WL54 WL55 WL56 WL57 WL58 WL59 WL60 WL61 WL62 WL63
+ SRAM_Column_64x1

xCOL2
+ PRE SAEN SENSE_OUT0 SENSE_OUTB0 WEN_BL0 WEN_BLB0 VDD GND
+ WL0 WL1 WL2 WL3 WL4 WL5 WL6 WL7 WL8 WL9 WL10 WL11 WL12 WL13 WL14 WL15
+ WL16 WL17 WL18 WL19 WL20 WL21 WL22 WL23 WL24 WL25 WL26 WL27 WL28 WL29 WL30 WL31
+ WL32 WL33 WL34 WL35 WL36 WL37 WL38 WL39 WL40 WL41 WL42 WL43 WL44 WL45 WL46 WL47
+ WL48 WL49 WL50 WL51 WL52 WL53 WL54 WL55 WL56 WL57 WL58 WL59 WL60 WL61 WL62 WL63
+ SRAM_Column_64x1

xCOL3
+ PRE SAEN SENSE_OUT1 SENSE_OUTB1 WEN_BL1 WEN_BLB1 VDD GND
+ WL0 WL1 WL2 WL3 WL4 WL5 WL6 WL7 WL8 WL9 WL10 WL11 WL12 WL13 WL14 WL15
+ WL16 WL17 WL18 WL19 WL20 WL21 WL22 WL23 WL24 WL25 WL26 WL27 WL28 WL29 WL30 WL31
+ WL32 WL33 WL34 WL35 WL36 WL37 WL38 WL39 WL40 WL41 WL42 WL43 WL44 WL45 WL46 WL47
+ WL48 WL49 WL50 WL51 WL52 WL53 WL54 WL55 WL56 WL57 WL58 WL59 WL60 WL61 WL62 WL63
+ SRAM_Column_64x1

xCOL4
+ PRE SAEN SENSE_OUT0 SENSE_OUTB0 WEN_BL0 WEN_BLB0 VDD GND
+ WL0 WL1 WL2 WL3 WL4 WL5 WL6 WL7 WL8 WL9 WL10 WL11 WL12 WL13 WL14 WL15
+ WL16 WL17 WL18 WL19 WL20 WL21 WL22 WL23 WL24 WL25 WL26 WL27 WL28 WL29 WL30 WL31
+ WL32 WL33 WL34 WL35 WL36 WL37 WL38 WL39 WL40 WL41 WL42 WL43 WL44 WL45 WL46 WL47
+ WL48 WL49 WL50 WL51 WL52 WL53 WL54 WL55 WL56 WL57 WL58 WL59 WL60 WL61 WL62 WL63
+ SRAM_Column_64x1

xCOL5
+ PRE SAEN SENSE_OUT1 SENSE_OUTB1 WEN_BL1 WEN_BLB1 VDD GND
+ WL0 WL1 WL2 WL3 WL4 WL5 WL6 WL7 WL8 WL9 WL10 WL11 WL12 WL13 WL14 WL15
+ WL16 WL17 WL18 WL19 WL20 WL21 WL22 WL23 WL24 WL25 WL26 WL27 WL28 WL29 WL30 WL31
+ WL32 WL33 WL34 WL35 WL36 WL37 WL38 WL39 WL40 WL41 WL42 WL43 WL44 WL45 WL46 WL47
+ WL48 WL49 WL50 WL51 WL52 WL53 WL54 WL55 WL56 WL57 WL58 WL59 WL60 WL61 WL62 WL63
+ SRAM_Column_64x1

xCOL6
+ PRE SAEN SENSE_OUT0 SENSE_OUTB0 WEN_BL0 WEN_BLB0 VDD GND
+ WL0 WL1 WL2 WL3 WL4 WL5 WL6 WL7 WL8 WL9 WL10 WL11 WL12 WL13 WL14 WL15
+ WL16 WL17 WL18 WL19 WL20 WL21 WL22 WL23 WL24 WL25 WL26 WL27 WL28 WL29 WL30 WL31
+ WL32 WL33 WL34 WL35 WL36 WL37 WL38 WL39 WL40 WL41 WL42 WL43 WL44 WL45 WL46 WL47
+ WL48 WL49 WL50 WL51 WL52 WL53 WL54 WL55 WL56 WL57 WL58 WL59 WL60 WL61 WL62 WL63
+ SRAM_Column_64x1

xCOL7
+ PRE SAEN SENSE_OUT1 SENSE_OUTB1 WEN_BL1 WEN_BLB1 VDD GND
+ WL0 WL1 WL2 WL3 WL4 WL5 WL6 WL7 WL8 WL9 WL10 WL11 WL12 WL13 WL14 WL15
+ WL16 WL17 WL18 WL19 WL20 WL21 WL22 WL23 WL24 WL25 WL26 WL27 WL28 WL29 WL30 WL31
+ WL32 WL33 WL34 WL35 WL36 WL37 WL38 WL39 WL40 WL41 WL42 WL43 WL44 WL45 WL46 WL47
+ WL48 WL49 WL50 WL51 WL52 WL53 WL54 WL55 WL56 WL57 WL58 WL59 WL60 WL61 WL62 WL63
+ SRAM_Column_64x1

xCOL8
+ PRE SAEN SENSE_OUT0 SENSE_OUTB0 WEN_BL0 WEN_BLB0 VDD GND
+ WL0 WL1 WL2 WL3 WL4 WL5 WL6 WL7 WL8 WL9 WL10 WL11 WL12 WL13 WL14 WL15
+ WL16 WL17 WL18 WL19 WL20 WL21 WL22 WL23 WL24 WL25 WL26 WL27 WL28 WL29 WL30 WL31
+ WL32 WL33 WL34 WL35 WL36 WL37 WL38 WL39 WL40 WL41 WL42 WL43 WL44 WL45 WL46 WL47
+ WL48 WL49 WL50 WL51 WL52 WL53 WL54 WL55 WL56 WL57 WL58 WL59 WL60 WL61 WL62 WL63
+ SRAM_Column_64x1

xCOL9
+ PRE SAEN SENSE_OUT1 SENSE_OUTB1 WEN_BL1 WEN_BLB1 VDD GND
+ WL0 WL1 WL2 WL3 WL4 WL5 WL6 WL7 WL8 WL9 WL10 WL11 WL12 WL13 WL14 WL15
+ WL16 WL17 WL18 WL19 WL20 WL21 WL22 WL23 WL24 WL25 WL26 WL27 WL28 WL29 WL30 WL31
+ WL32 WL33 WL34 WL35 WL36 WL37 WL38 WL39 WL40 WL41 WL42 WL43 WL44 WL45 WL46 WL47
+ WL48 WL49 WL50 WL51 WL52 WL53 WL54 WL55 WL56 WL57 WL58 WL59 WL60 WL61 WL62 WL63
+ SRAM_Column_64x1

xCOL10
+ PRE SAEN SENSE_OUT0 SENSE_OUTB0 WEN_BL0 WEN_BLB0 VDD GND
+ WL0 WL1 WL2 WL3 WL4 WL5 WL6 WL7 WL8 WL9 WL10 WL11 WL12 WL13 WL14 WL15
+ WL16 WL17 WL18 WL19 WL20 WL21 WL22 WL23 WL24 WL25 WL26 WL27 WL28 WL29 WL30 WL31
+ WL32 WL33 WL34 WL35 WL36 WL37 WL38 WL39 WL40 WL41 WL42 WL43 WL44 WL45 WL46 WL47
+ WL48 WL49 WL50 WL51 WL52 WL53 WL54 WL55 WL56 WL57 WL58 WL59 WL60 WL61 WL62 WL63
+ SRAM_Column_64x1

xCOL11
+ PRE SAEN SENSE_OUT1 SENSE_OUTB1 WEN_BL1 WEN_BLB1 VDD GND
+ WL0 WL1 WL2 WL3 WL4 WL5 WL6 WL7 WL8 WL9 WL10 WL11 WL12 WL13 WL14 WL15
+ WL16 WL17 WL18 WL19 WL20 WL21 WL22 WL23 WL24 WL25 WL26 WL27 WL28 WL29 WL30 WL31
+ WL32 WL33 WL34 WL35 WL36 WL37 WL38 WL39 WL40 WL41 WL42 WL43 WL44 WL45 WL46 WL47
+ WL48 WL49 WL50 WL51 WL52 WL53 WL54 WL55 WL56 WL57 WL58 WL59 WL60 WL61 WL62 WL63
+ SRAM_Column_64x1

xCOL12
+ PRE SAEN SENSE_OUT0 SENSE_OUTB0 WEN_BL0 WEN_BLB0 VDD GND
+ WL0 WL1 WL2 WL3 WL4 WL5 WL6 WL7 WL8 WL9 WL10 WL11 WL12 WL13 WL14 WL15
+ WL16 WL17 WL18 WL19 WL20 WL21 WL22 WL23 WL24 WL25 WL26 WL27 WL28 WL29 WL30 WL31
+ WL32 WL33 WL34 WL35 WL36 WL37 WL38 WL39 WL40 WL41 WL42 WL43 WL44 WL45 WL46 WL47
+ WL48 WL49 WL50 WL51 WL52 WL53 WL54 WL55 WL56 WL57 WL58 WL59 WL60 WL61 WL62 WL63
+ SRAM_Column_64x1

xCOL13
+ PRE SAEN SENSE_OUT1 SENSE_OUTB1 WEN_BL1 WEN_BLB1 VDD GND
+ WL0 WL1 WL2 WL3 WL4 WL5 WL6 WL7 WL8 WL9 WL10 WL11 WL12 WL13 WL14 WL15
+ WL16 WL17 WL18 WL19 WL20 WL21 WL22 WL23 WL24 WL25 WL26 WL27 WL28 WL29 WL30 WL31
+ WL32 WL33 WL34 WL35 WL36 WL37 WL38 WL39 WL40 WL41 WL42 WL43 WL44 WL45 WL46 WL47
+ WL48 WL49 WL50 WL51 WL52 WL53 WL54 WL55 WL56 WL57 WL58 WL59 WL60 WL61 WL62 WL63
+ SRAM_Column_64x1

xCOL14
+ PRE SAEN SENSE_OUT0 SENSE_OUTB0 WEN_BL0 WEN_BLB0 VDD GND
+ WL0 WL1 WL2 WL3 WL4 WL5 WL6 WL7 WL8 WL9 WL10 WL11 WL12 WL13 WL14 WL15
+ WL16 WL17 WL18 WL19 WL20 WL21 WL22 WL23 WL24 WL25 WL26 WL27 WL28 WL29 WL30 WL31
+ WL32 WL33 WL34 WL35 WL36 WL37 WL38 WL39 WL40 WL41 WL42 WL43 WL44 WL45 WL46 WL47
+ WL48 WL49 WL50 WL51 WL52 WL53 WL54 WL55 WL56 WL57 WL58 WL59 WL60 WL61 WL62 WL63
+ SRAM_Column_64x1

xCOL15
+ PRE SAEN SENSE_OUT1 SENSE_OUTB1 WEN_BL1 WEN_BLB1 VDD GND
+ WL0 WL1 WL2 WL3 WL4 WL5 WL6 WL7 WL8 WL9 WL10 WL11 WL12 WL13 WL14 WL15
+ WL16 WL17 WL18 WL19 WL20 WL21 WL22 WL23 WL24 WL25 WL26 WL27 WL28 WL29 WL30 WL31
+ WL32 WL33 WL34 WL35 WL36 WL37 WL38 WL39 WL40 WL41 WL42 WL43 WL44 WL45 WL46 WL47
+ WL48 WL49 WL50 WL51 WL52 WL53 WL54 WL55 WL56 WL57 WL58 WL59 WL60 WL61 WL62 WL63
+ SRAM_Column_64x1

xCOL16
+ PRE SAEN SENSE_OUT0 SENSE_OUTB0 WEN_BL0 WEN_BLB0 VDD GND
+ WL0 WL1 WL2 WL3 WL4 WL5 WL6 WL7 WL8 WL9 WL10 WL11 WL12 WL13 WL14 WL15
+ WL16 WL17 WL18 WL19 WL20 WL21 WL22 WL23 WL24 WL25 WL26 WL27 WL28 WL29 WL30 WL31
+ WL32 WL33 WL34 WL35 WL36 WL37 WL38 WL39 WL40 WL41 WL42 WL43 WL44 WL45 WL46 WL47
+ WL48 WL49 WL50 WL51 WL52 WL53 WL54 WL55 WL56 WL57 WL58 WL59 WL60 WL61 WL62 WL63
+ SRAM_Column_64x1

xCOL17
+ PRE SAEN SENSE_OUT1 SENSE_OUTB1 WEN_BL1 WEN_BLB1 VDD GND
+ WL0 WL1 WL2 WL3 WL4 WL5 WL6 WL7 WL8 WL9 WL10 WL11 WL12 WL13 WL14 WL15
+ WL16 WL17 WL18 WL19 WL20 WL21 WL22 WL23 WL24 WL25 WL26 WL27 WL28 WL29 WL30 WL31
+ WL32 WL33 WL34 WL35 WL36 WL37 WL38 WL39 WL40 WL41 WL42 WL43 WL44 WL45 WL46 WL47
+ WL48 WL49 WL50 WL51 WL52 WL53 WL54 WL55 WL56 WL57 WL58 WL59 WL60 WL61 WL62 WL63
+ SRAM_Column_64x1

xCOL18
+ PRE SAEN SENSE_OUT0 SENSE_OUTB0 WEN_BL0 WEN_BLB0 VDD GND
+ WL0 WL1 WL2 WL3 WL4 WL5 WL6 WL7 WL8 WL9 WL10 WL11 WL12 WL13 WL14 WL15
+ WL16 WL17 WL18 WL19 WL20 WL21 WL22 WL23 WL24 WL25 WL26 WL27 WL28 WL29 WL30 WL31
+ WL32 WL33 WL34 WL35 WL36 WL37 WL38 WL39 WL40 WL41 WL42 WL43 WL44 WL45 WL46 WL47
+ WL48 WL49 WL50 WL51 WL52 WL53 WL54 WL55 WL56 WL57 WL58 WL59 WL60 WL61 WL62 WL63
+ SRAM_Column_64x1

xCOL19
+ PRE SAEN SENSE_OUT1 SENSE_OUTB1 WEN_BL1 WEN_BLB1 VDD GND
+ WL0 WL1 WL2 WL3 WL4 WL5 WL6 WL7 WL8 WL9 WL10 WL11 WL12 WL13 WL14 WL15
+ WL16 WL17 WL18 WL19 WL20 WL21 WL22 WL23 WL24 WL25 WL26 WL27 WL28 WL29 WL30 WL31
+ WL32 WL33 WL34 WL35 WL36 WL37 WL38 WL39 WL40 WL41 WL42 WL43 WL44 WL45 WL46 WL47
+ WL48 WL49 WL50 WL51 WL52 WL53 WL54 WL55 WL56 WL57 WL58 WL59 WL60 WL61 WL62 WL63
+ SRAM_Column_64x1

xCOL20
+ PRE SAEN SENSE_OUT0 SENSE_OUTB0 WEN_BL0 WEN_BLB0 VDD GND
+ WL0 WL1 WL2 WL3 WL4 WL5 WL6 WL7 WL8 WL9 WL10 WL11 WL12 WL13 WL14 WL15
+ WL16 WL17 WL18 WL19 WL20 WL21 WL22 WL23 WL24 WL25 WL26 WL27 WL28 WL29 WL30 WL31
+ WL32 WL33 WL34 WL35 WL36 WL37 WL38 WL39 WL40 WL41 WL42 WL43 WL44 WL45 WL46 WL47
+ WL48 WL49 WL50 WL51 WL52 WL53 WL54 WL55 WL56 WL57 WL58 WL59 WL60 WL61 WL62 WL63
+ SRAM_Column_64x1

xCOL21
+ PRE SAEN SENSE_OUT1 SENSE_OUTB1 WEN_BL1 WEN_BLB1 VDD GND
+ WL0 WL1 WL2 WL3 WL4 WL5 WL6 WL7 WL8 WL9 WL10 WL11 WL12 WL13 WL14 WL15
+ WL16 WL17 WL18 WL19 WL20 WL21 WL22 WL23 WL24 WL25 WL26 WL27 WL28 WL29 WL30 WL31
+ WL32 WL33 WL34 WL35 WL36 WL37 WL38 WL39 WL40 WL41 WL42 WL43 WL44 WL45 WL46 WL47
+ WL48 WL49 WL50 WL51 WL52 WL53 WL54 WL55 WL56 WL57 WL58 WL59 WL60 WL61 WL62 WL63
+ SRAM_Column_64x1

xCOL22
+ PRE SAEN SENSE_OUT0 SENSE_OUTB0 WEN_BL0 WEN_BLB0 VDD GND
+ WL0 WL1 WL2 WL3 WL4 WL5 WL6 WL7 WL8 WL9 WL10 WL11 WL12 WL13 WL14 WL15
+ WL16 WL17 WL18 WL19 WL20 WL21 WL22 WL23 WL24 WL25 WL26 WL27 WL28 WL29 WL30 WL31
+ WL32 WL33 WL34 WL35 WL36 WL37 WL38 WL39 WL40 WL41 WL42 WL43 WL44 WL45 WL46 WL47
+ WL48 WL49 WL50 WL51 WL52 WL53 WL54 WL55 WL56 WL57 WL58 WL59 WL60 WL61 WL62 WL63
+ SRAM_Column_64x1

xCOL23
+ PRE SAEN SENSE_OUT1 SENSE_OUTB1 WEN_BL1 WEN_BLB1 VDD GND
+ WL0 WL1 WL2 WL3 WL4 WL5 WL6 WL7 WL8 WL9 WL10 WL11 WL12 WL13 WL14 WL15
+ WL16 WL17 WL18 WL19 WL20 WL21 WL22 WL23 WL24 WL25 WL26 WL27 WL28 WL29 WL30 WL31
+ WL32 WL33 WL34 WL35 WL36 WL37 WL38 WL39 WL40 WL41 WL42 WL43 WL44 WL45 WL46 WL47
+ WL48 WL49 WL50 WL51 WL52 WL53 WL54 WL55 WL56 WL57 WL58 WL59 WL60 WL61 WL62 WL63
+ SRAM_Column_64x1

xCOL24
+ PRE SAEN SENSE_OUT0 SENSE_OUTB0 WEN_BL0 WEN_BLB0 VDD GND
+ WL0 WL1 WL2 WL3 WL4 WL5 WL6 WL7 WL8 WL9 WL10 WL11 WL12 WL13 WL14 WL15
+ WL16 WL17 WL18 WL19 WL20 WL21 WL22 WL23 WL24 WL25 WL26 WL27 WL28 WL29 WL30 WL31
+ WL32 WL33 WL34 WL35 WL36 WL37 WL38 WL39 WL40 WL41 WL42 WL43 WL44 WL45 WL46 WL47
+ WL48 WL49 WL50 WL51 WL52 WL53 WL54 WL55 WL56 WL57 WL58 WL59 WL60 WL61 WL62 WL63
+ SRAM_Column_64x1

xCOL25
+ PRE SAEN SENSE_OUT1 SENSE_OUTB1 WEN_BL1 WEN_BLB1 VDD GND
+ WL0 WL1 WL2 WL3 WL4 WL5 WL6 WL7 WL8 WL9 WL10 WL11 WL12 WL13 WL14 WL15
+ WL16 WL17 WL18 WL19 WL20 WL21 WL22 WL23 WL24 WL25 WL26 WL27 WL28 WL29 WL30 WL31
+ WL32 WL33 WL34 WL35 WL36 WL37 WL38 WL39 WL40 WL41 WL42 WL43 WL44 WL45 WL46 WL47
+ WL48 WL49 WL50 WL51 WL52 WL53 WL54 WL55 WL56 WL57 WL58 WL59 WL60 WL61 WL62 WL63
+ SRAM_Column_64x1

xCOL26
+ PRE SAEN SENSE_OUT0 SENSE_OUTB0 WEN_BL0 WEN_BLB0 VDD GND
+ WL0 WL1 WL2 WL3 WL4 WL5 WL6 WL7 WL8 WL9 WL10 WL11 WL12 WL13 WL14 WL15
+ WL16 WL17 WL18 WL19 WL20 WL21 WL22 WL23 WL24 WL25 WL26 WL27 WL28 WL29 WL30 WL31
+ WL32 WL33 WL34 WL35 WL36 WL37 WL38 WL39 WL40 WL41 WL42 WL43 WL44 WL45 WL46 WL47
+ WL48 WL49 WL50 WL51 WL52 WL53 WL54 WL55 WL56 WL57 WL58 WL59 WL60 WL61 WL62 WL63
+ SRAM_Column_64x1

xCOL27
+ PRE SAEN SENSE_OUT1 SENSE_OUTB1 WEN_BL1 WEN_BLB1 VDD GND
+ WL0 WL1 WL2 WL3 WL4 WL5 WL6 WL7 WL8 WL9 WL10 WL11 WL12 WL13 WL14 WL15
+ WL16 WL17 WL18 WL19 WL20 WL21 WL22 WL23 WL24 WL25 WL26 WL27 WL28 WL29 WL30 WL31
+ WL32 WL33 WL34 WL35 WL36 WL37 WL38 WL39 WL40 WL41 WL42 WL43 WL44 WL45 WL46 WL47
+ WL48 WL49 WL50 WL51 WL52 WL53 WL54 WL55 WL56 WL57 WL58 WL59 WL60 WL61 WL62 WL63
+ SRAM_Column_64x1

xCOL28
+ PRE SAEN SENSE_OUT0 SENSE_OUTB0 WEN_BL0 WEN_BLB0 VDD GND
+ WL0 WL1 WL2 WL3 WL4 WL5 WL6 WL7 WL8 WL9 WL10 WL11 WL12 WL13 WL14 WL15
+ WL16 WL17 WL18 WL19 WL20 WL21 WL22 WL23 WL24 WL25 WL26 WL27 WL28 WL29 WL30 WL31
+ WL32 WL33 WL34 WL35 WL36 WL37 WL38 WL39 WL40 WL41 WL42 WL43 WL44 WL45 WL46 WL47
+ WL48 WL49 WL50 WL51 WL52 WL53 WL54 WL55 WL56 WL57 WL58 WL59 WL60 WL61 WL62 WL63
+ SRAM_Column_64x1

xCOL29
+ PRE SAEN SENSE_OUT1 SENSE_OUTB1 WEN_BL1 WEN_BLB1 VDD GND
+ WL0 WL1 WL2 WL3 WL4 WL5 WL6 WL7 WL8 WL9 WL10 WL11 WL12 WL13 WL14 WL15
+ WL16 WL17 WL18 WL19 WL20 WL21 WL22 WL23 WL24 WL25 WL26 WL27 WL28 WL29 WL30 WL31
+ WL32 WL33 WL34 WL35 WL36 WL37 WL38 WL39 WL40 WL41 WL42 WL43 WL44 WL45 WL46 WL47
+ WL48 WL49 WL50 WL51 WL52 WL53 WL54 WL55 WL56 WL57 WL58 WL59 WL60 WL61 WL62 WL63
+ SRAM_Column_64x1

xCOL30
+ PRE SAEN SENSE_OUT0 SENSE_OUTB0 WEN_BL0 WEN_BLB0 VDD GND
+ WL0 WL1 WL2 WL3 WL4 WL5 WL6 WL7 WL8 WL9 WL10 WL11 WL12 WL13 WL14 WL15
+ WL16 WL17 WL18 WL19 WL20 WL21 WL22 WL23 WL24 WL25 WL26 WL27 WL28 WL29 WL30 WL31
+ WL32 WL33 WL34 WL35 WL36 WL37 WL38 WL39 WL40 WL41 WL42 WL43 WL44 WL45 WL46 WL47
+ WL48 WL49 WL50 WL51 WL52 WL53 WL54 WL55 WL56 WL57 WL58 WL59 WL60 WL61 WL62 WL63
+ SRAM_Column_64x1

xCOL31
+ PRE SAEN SENSE_OUT31 SENSE_OUTB31 WEN_BL31 WEN_BLB31 VDD GND
+ WL0 WL1 WL2 WL3 WL4 WL5 WL6 WL7 WL8 WL9 WL10 WL11 WL12 WL13 WL14 WL15
+ WL16 WL17 WL18 WL19 WL20 WL21 WL22 WL23 WL24 WL25 WL26 WL27 WL28 WL29 WL30 WL31
+ WL32 WL33 WL34 WL35 WL36 WL37 WL38 WL39 WL40 WL41 WL42 WL43 WL44 WL45 WL46 WL47
+ WL48 WL49 WL50 WL51 WL52 WL53 WL54 WL55 WL56 WL57 WL58 WL59 WL60 WL61 WL62 WL63
+ SRAM_Column_64x1

.ends SRAM_Array_64x32
