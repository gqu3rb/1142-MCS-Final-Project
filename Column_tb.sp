.title SRAM and Sense Amplifier Simulation
*****************************
**     Library setting     **
*****************************
.protect
.include '7nm_TT.pm'
.unprotect
.include '6to64_row_decoder.sp'
.include 'SRAM_array_64x32.sp'
.include 'column_based_circuit.sp'

*****************************
**   Circuit Description   **
*****************************
* 呼叫 Row Decoder (注意：引腳順序必須跟上面定義的完全一模一樣)
xdecoder A6 A5 A4 A3 A2 A1
+ WL0 WL1 WL2 WL3 WL4 WL5 WL6 WL7 WL8 WL9 WL10 WL11 WL12 WL13 WL14 WL15
+ WL16 WL17 WL18 WL19 WL20 WL21 WL22 WL23 WL24 WL25 WL26 WL27 WL28 WL29 WL30 WL31
+ WL32 WL33 WL34 WL35 WL36 WL37 WL38 WL39 WL40 WL41 WL42 WL43 WL44 WL45 WL46 WL47
+ WL48 WL49 WL50 WL51 WL52 WL53 WL54 WL55 WL56 WL57 WL58 WL59 WL60 WL61 WL62 WL63
+ ROW_DEC_6to64

XARRAY_TOP PRE SAEN VDD GND
+ WL0 WL1 WL2 WL3 WL4 WL5 WL6 WL7 WL8 WL9 WL10 WL11 WL12 WL13 WL14 WL15
+ WL16 WL17 WL18 WL19 WL20 WL21 WL22 WL23 WL24 WL25 WL26 WL27 WL28 WL29 WL30 WL31
+ WL32 WL33 WL34 WL35 WL36 WL37 WL38 WL39 WL40 WL41 WL42 WL43 WL44 WL45 WL46 WL47
+ WL48 WL49 WL50 WL51 WL52 WL53 WL54 WL55 WL56 WL57 WL58 WL59 WL60 WL61 WL62 WL63
+ SENSE_OUT0  SENSE_OUTB0  WEN_BL0  WEN_BLB0
+ SENSE_OUT1  SENSE_OUTB1  WEN_BL1  WEN_BLB1
+ SENSE_OUT2  SENSE_OUTB2  WEN_BL2  WEN_BLB2
+ SENSE_OUT3  SENSE_OUTB3  WEN_BL3  WEN_BLB3
+ SENSE_OUT4  SENSE_OUTB4  WEN_BL4  WEN_BLB4
+ SENSE_OUT5  SENSE_OUTB5  WEN_BL5  WEN_BLB5
+ SENSE_OUT6  SENSE_OUTB6  WEN_BL6  WEN_BLB6
+ SENSE_OUT7  SENSE_OUTB7  WEN_BL7  WEN_BLB7
+ SENSE_OUT8  SENSE_OUTB8  WEN_BL8  WEN_BLB8
+ SENSE_OUT9  SENSE_OUTB9  WEN_BL9  WEN_BLB9
+ SENSE_OUT10 SENSE_OUTB10 WEN_BL10 WEN_BLB10
+ SENSE_OUT11 SENSE_OUTB11 WEN_BL11 WEN_BLB11
+ SENSE_OUT12 SENSE_OUTB12 WEN_BL12 WEN_BLB12
+ SENSE_OUT13 SENSE_OUTB13 WEN_BL13 WEN_BLB13
+ SENSE_OUT14 SENSE_OUTB14 WEN_BL14 WEN_BLB14
+ SENSE_OUT15 SENSE_OUTB15 WEN_BL15 WEN_BLB15
+ SENSE_OUT16 SENSE_OUTB16 WEN_BL16 WEN_BLB16
+ SENSE_OUT17 SENSE_OUTB17 WEN_BL17 WEN_BLB17
+ SENSE_OUT18 SENSE_OUTB18 WEN_BL18 WEN_BLB18
+ SENSE_OUT19 SENSE_OUTB19 WEN_BL19 WEN_BLB19
+ SENSE_OUT20 SENSE_OUTB20 WEN_BL20 WEN_BLB20
+ SENSE_OUT21 SENSE_OUTB21 WEN_BL21 WEN_BLB21
+ SENSE_OUT22 SENSE_OUTB22 WEN_BL22 WEN_BLB22
+ SENSE_OUT23 SENSE_OUTB23 WEN_BL23 WEN_BLB23
+ SENSE_OUT24 SENSE_OUTB24 WEN_BL24 WEN_BLB24
+ SENSE_OUT25 SENSE_OUTB25 WEN_BL25 WEN_BLB25
+ SENSE_OUT26 SENSE_OUTB26 WEN_BL26 WEN_BLB26
+ SENSE_OUT27 SENSE_OUTB27 WEN_BL27 WEN_BLB27
+ SENSE_OUT28 SENSE_OUTB28 WEN_BL28 WEN_BLB28
+ SENSE_OUT29 SENSE_OUTB29 WEN_BL29 WEN_BLB29
+ SENSE_OUT30 SENSE_OUTB30 WEN_BL30 WEN_BLB30
+ SENSE_OUT31 SENSE_OUTB31 WEN_BL31 WEN_BLB31
+ SRAM_Array_64x32

Xcol_driver_array_w A0 WEN
+ D0  D1  D2  D3  D4  D5  D6  D7
+ D8  D9  D10 D11 D12 D13 D14 D15
+ WEN_BL0  WEN_BL1  WEN_BL2  WEN_BL3  WEN_BL4  WEN_BL5  WEN_BL6  WEN_BL7
+ WEN_BL8  WEN_BL9  WEN_BL10 WEN_BL11 WEN_BL12 WEN_BL13 WEN_BL14 WEN_BL15
+ WEN_BL16 WEN_BL17 WEN_BL18 WEN_BL19 WEN_BL20 WEN_BL21 WEN_BL22 WEN_BL23
+ WEN_BL24 WEN_BL25 WEN_BL26 WEN_BL27 WEN_BL28 WEN_BL29 WEN_BL30 WEN_BL31
+ WEN_BLB0 WEN_BLB1 WEN_BLB2 WEN_BLB3 WEN_BLB4 WEN_BLB5 WEN_BLB6 WEN_BLB7
+ WEN_BLB8 WEN_BLB9 WEN_BLB10 WEN_BLB11 WEN_BLB12 WEN_BLB13 WEN_BLB14 WEN_BLB15
+ WEN_BLB16 WEN_BLB17 WEN_BLB18 WEN_BLB19 WEN_BLB20 WEN_BLB21 WEN_BLB22 WEN_BLB23
+ WEN_BLB24 WEN_BLB25 WEN_BLB26 WEN_BLB27 WEN_BLB28 WEN_BLB29 WEN_BLB30 WEN_BLB31
+ COL_DRIVER_ARRAY

Xcol_selector_r A0 WEN
+ Q0  Q1  Q2  Q3  Q4  Q5  Q6  Q7
+ Q8  Q9  Q10 Q11 Q12 Q13 Q14 Q15
+ QB0  QB1  QB2  QB3  QB4  QB5  QB6  QB7
+ QB8  QB9  QB10 QB11 QB12 QB13 QB14 QB15
+ SENSE_OUT0  SENSE_OUT1  SENSE_OUT2  SENSE_OUT3  SENSE_OUT4  SENSE_OUT5  SENSE_OUT6  SENSE_OUT7
+ SENSE_OUT8  SENSE_OUT9  SENSE_OUT10 SENSE_OUT11 SENSE_OUT12 SENSE_OUT13 SENSE_OUT14 SENSE_OUT15
+ SENSE_OUT16 SENSE_OUT17 SENSE_OUT18 SENSE_OUT19 SENSE_OUT20 SENSE_OUT21 SENSE_OUT22 SENSE_OUT23
+ SENSE_OUT24 SENSE_OUT25 SENSE_OUT26 SENSE_OUT27 SENSE_OUT28 SENSE_OUT29 SENSE_OUT30 SENSE_OUT31
+ SENSE_OUTB0  SENSE_OUTB1  SENSE_OUTB2  SENSE_OUTB3  SENSE_OUTB4  SENSE_OUTB5  SENSE_OUTB6  SENSE_OUTB7
+ SENSE_OUTB8  SENSE_OUTB9  SENSE_OUTB10 SENSE_OUTB11 SENSE_OUTB12 SENSE_OUTB13 SENSE_OUTB14 SENSE_OUTB15
+ SENSE_OUTB16 SENSE_OUTB17 SENSE_OUTB18 SENSE_OUTB19 SENSE_OUTB20 SENSE_OUTB21 SENSE_OUTB22 SENSE_OUTB23
+ SENSE_OUTB24 SENSE_OUTB25 SENSE_OUTB26 SENSE_OUTB27 SENSE_OUTB28 SENSE_OUTB29 SENSE_OUTB30 SENSE_OUTB31
+ COL_SEL

*****************************
**     Voltage Source      **
*****************************
* Do not modify below *
.global VDD GND
.param  BITCAP = 10f

VVDD VDD GND 0.7v

*CBLB BLB GND BITCAP
*CBL  BL  GND BITCAP

VA0 A0 GND 0V
VA1 A1 GND 0V
VA2 A2 GND 0V
VA3 A3 GND 0V
VA4 A4 GND 0V
VA5 A5 GND 0V
VA6 A6 GND 0V

*Read model voltage supply
*Vp PRE  GND PULSE  ( 0V  0.7V     4ns  0.05ns  0.05ns  0.35ns  1ns )
*Vs SAEN GND PULSE  ( 0V  0.7V  4.25ns  0.05ns  0.05ns  0.1ns   1ns )
*VWEN WEN GND  0.7V

*write model voltage supply
Vp PRE  GND PULSE  ( 0V  0.7V  4ns  0.05ns  0.05ns  0.35ns  1ns )
Vs SAEN GND 0V
*WEN=0 -> write, WEN=1 -> read
VWEN WEN GND  PULSE  ( 0.7V  0V  4ns  0.05ns  0.05ns  0.3ns   1ns )

Vd0 D0 GND 0V
Vd1 D1 GND 0V
Vd2 D2 GND 0V
Vd3 D3 GND 0V
Vd4 D4 GND 0V
Vd5 D5 GND 0V
Vd6 D6 GND 0V
Vd7 D7 GND 0V
Vd8 D8 GND 0V
Vd9 D9 GND 0V
Vd10 D10 GND 0V
Vd11 D11 GND 0V
Vd12 D12 GND 0V
Vd13 D13 GND 0V
Vd14 D14 GND 0V
Vd15 D15 GND 0V

*****************************
**    Initial Conditions   **
*****************************
* Do not modify the initial conditions for BL and BLB, which are both 0V.
* We assume there is no initial voltage on the bitlines before precharge.
.ic v(XARRAY_TOP.xCOL0.BL0)  = 0v
.ic v(XARRAY_TOP.xCOL0.BLB0) = 0v
.ic v(XARRAY_TOP.xCOL1.BL0)  = 0v
.ic v(XARRAY_TOP.xCOL1.BLB0) = 0v

* You should set the initial conditions for q and qb in the SRAM.
* q should be 0V and qb should be 0.7V, which means the SRAM cell is storing "0".
.ic v(XARRAY_TOP.xCOL0.q0) = 0v
.ic v(XARRAY_TOP.xCOL0.qb0) = 0.7v
.ic v(XARRAY_TOP.xCOL1.q0) = 0v
.ic v(XARRAY_TOP.xCOL1.qb0) = 0.7v

*****************************
**    Simulator setting    **
*****************************
.op
.option post
.options probe
.probe v(*) i(*)

* Do Not Modify !!!
.tran 0.05ns 5ns

*read model
*.measure tp
*+ TRIG v(SAEN) VAL='0.35' rise=1
*+ TARG v(sense) VAL='0.35' fall=1

*write model
.measure tp_write
+ TRIG v(WEN) VAL='0.35' fall=1
+ TARG v(XARRAY_TOP.xCOL0.q0) VAL='0.35'

.probe tran v(XARRAY_TOP.xCOL0.q0) v(XARRAY_TOP.xCOL0.qb0) v(XARRAY_TOP.xCOL0.BL) v(XARRAY_TOP.xCOL0.BLB)
.probe tran v(XARRAY_TOP.xCOL1.q0) v(XARRAY_TOP.xCOL1.qb0)
.measure TRAN Avg_read_pwr avg POWER from=4n to=5n

.end
