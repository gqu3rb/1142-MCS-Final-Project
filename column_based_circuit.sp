.title column decoder 1to2 x16
* ===================================================================
* 獨立元件庫：Column-based Peripheral Circuits
* 檔名：column_based_circuit.sp
* ===================================================================

* ------ 1. 基礎邏輯閘子電路(column decoder) ------
.subckt INV_c IN OUT
Mp OUT IN VDD VDD pmos_lvt m=1
Mn OUT IN GND GND nmos_lvt m=1
.ends

.subckt DEC_1to2 IN OUT_b OUT
Xsel0 IN   OUT_b INV_c
Xsel1 OUT_b OUT INV_c
.ends

.subckt AND2_c IN1 IN2 OUT
Mp1 OUT_b IN1 VDD VDD pmos_lvt m=1
Mp2 OUT_b IN2 VDD VDD pmos_lvt m=1
Mn1 OUT_b IN1 n1  GND nmos_lvt m=1
Mn2 n1    IN2 GND GND nmos_lvt m=1
Xinv OUT_b OUT INV_c
.ends

.subckt WR_DRIVER WEN IN BL BLB
Xinv  IN  IN_b INV_c
Xand1 WEN IN   BL  AND2_c
Xand2 WEN IN_b BLB AND2_c
.ends

.subckt bl_to_wen_slice EN A A_b D WEN_BL0 WEN_BLB0 WEN_BL1 WEN_BLB1
Xand0 EN A_b WEN0 AND2_c
Xand1 EN A   WEN1 AND2_c

Xdriver0 WEN0 D WEN_BL0 WEN_BLB0 WR_DRIVER
Xdriver1 WEN1 D WEN_BL1 WEN_BLB1 WR_DRIVER
.ends

* ------ 2. 主解碼器核心 ------
.subckt COL_DRIVER_ARRAY In WEN
+ D0  D1  D2  D3  D4  D5  D6  D7
+ D8  D9  D10 D11 D12 D13 D14 D15
+ WEN_BL0  WEN_BL1  WEN_BL2  WEN_BL3  WEN_BL4  WEN_BL5  WEN_BL6  WEN_BL7
+ WEN_BL8  WEN_BL9  WEN_BL10 WEN_BL11 WEN_BL12 WEN_BL13 WEN_BL14 WEN_BL15
+ WEN_BL16 WEN_BL17 WEN_BL18 WEN_BL19 WEN_BL20 WEN_BL21 WEN_BL22 WEN_BL23
+ WEN_BL24 WEN_BL25 WEN_BL26 WEN_BL27 WEN_BL28 WEN_BL29 WEN_BL30 WEN_BL31
+ WEN_BLB0 WEN_BLB1 WEN_BLB2 WEN_BLB3 WEN_BLB4 WEN_BLB5 WEN_BLB6 WEN_BLB7
+ WEN_BLB8 WEN_BLB9 WEN_BLB10 WEN_BLB11 WEN_BLB12 WEN_BLB13 WEN_BLB14 WEN_BLB15
+ WEN_BLB16 WEN_BLB17 WEN_BLB18 WEN_BLB19 WEN_BLB20 WEN_BLB21 WEN_BLB22 WEN_BLB23
+ WEN_BLB24 WEN_BLB25 WEN_BLB26 WEN_BLB27 WEN_BLB28 WEN_BLB29 WEN_BLB30 WEN_BLB31

Xdec In A0_b A0 DEC_1to2
Xinv1 A0   A1_b INV_c
Xinv2 A0_b A1   INV_c
Xinv3 A1   A2_b INV_c
Xinv4 A1_b A2   INV_c
Xinv5 A1   A3_b INV_c
Xinv6 A1_b A3   INV_c

Xinv_en1  WEN    WEN_b0 INV_c
Xinv_en2  WEN_b0 WEN1   INV_c
Xinv_en3  WEN1   WEN_b1 INV_c

X_slice0  WEN_b0 A0   A0_b   D0  WEN_BL0  WEN_BLB0  WEN_BL16 WEN_BLB16 bl_to_wen_slice
X_slice1  WEN_b0 A0   A0_b   D1  WEN_BL1  WEN_BLB1  WEN_BL17 WEN_BLB17 bl_to_wen_slice
X_slice2  WEN_b0 A0   A0_b   D2  WEN_BL2  WEN_BLB2  WEN_BL18 WEN_BLB18 bl_to_wen_slice
X_slice3  WEN_b0 A0   A0_b   D3  WEN_BL3  WEN_BLB3  WEN_BL19 WEN_BLB19 bl_to_wen_slice

X_slice4  WEN_b0 A1   A1_b   D4  WEN_BL4  WEN_BLB4  WEN_BL20 WEN_BLB20 bl_to_wen_slice
X_slice5  WEN_b0 A1   A1_b   D5  WEN_BL5  WEN_BLB5  WEN_BL21 WEN_BLB21 bl_to_wen_slice
X_slice6  WEN_b0 A1   A1_b   D6  WEN_BL6  WEN_BLB6  WEN_BL22 WEN_BLB22 bl_to_wen_slice
X_slice7  WEN_b0 A1   A1_b   D7  WEN_BL7  WEN_BLB7  WEN_BL23 WEN_BLB23 bl_to_wen_slice

X_slice8  WEN_b1 A2   A2_b   D8  WEN_BL8  WEN_BLB8  WEN_BL24 WEN_BLB24 bl_to_wen_slice
X_slice9  WEN_b1 A2   A2_b   D9  WEN_BL9  WEN_BLB9  WEN_BL25 WEN_BLB25 bl_to_wen_slice
X_slice10 WEN_b1 A2   A2_b   D10 WEN_BL10 WEN_BLB10 WEN_BL26 WEN_BLB26 bl_to_wen_slice
X_slice11 WEN_b1 A2   A2_b   D11 WEN_BL11 WEN_BLB11 WEN_BL27 WEN_BLB27 bl_to_wen_slice

X_slice12 WEN_b1 A3   A3_b   D12 WEN_BL12 WEN_BLB12 WEN_BL28 WEN_BLB28 bl_to_wen_slice
X_slice13 WEN_b1 A3   A3_b   D13 WEN_BL13 WEN_BLB13 WEN_BL29 WEN_BLB29 bl_to_wen_slice
X_slice14 WEN_b1 A3   A3_b   D14 WEN_BL14 WEN_BLB14 WEN_BL30 WEN_BLB30 bl_to_wen_slice
X_slice15 WEN_b1 A3   A3_b   D15 WEN_BL15 WEN_BLB15 WEN_BL31 WEN_BLB31 bl_to_wen_slice
.ends

* ------ 3. 基礎邏輯閘子電路(column selector) ------
.subckt SEL sel OUT1 OUT2 IN1 IN2
Mn1 IN1 sel OUT1 GND nmos_lvt m=1
Mn2 IN2 sel OUT2 GND nmos_lvt m=1
.ends

.subckt SEL_CHAIN In WEN
+ sel0_0  sel0_1
+ sel1_0  sel1_1
+ sel2_0  sel2_1
+ sel3_0  sel3_1
Xinv_en WEN    WEN_b  INV_c
Xand    WEN_b  IN     select AND2_c
Xdec    select sel0_0 sel0_1 DEC_1to2

Xinv0 sel0_0 sel1_1 INV_c
Xinv1 sel0_1 sel1_0 INV_c
Xinv3 sel1_0 sel2_1 INV_c
Xinv4 sel1_1 sel2_0 INV_c
Xinv5 sel2_0 sel3_1 INV_c
Xinv6 sel2_1 sel3_0 INV_c
.ends

* ------ 4. 主 column mutiplexer 核心 ------
.subckt COL_SEL IN WEN
+ Q0  Q1  Q2  Q3  Q4  Q5  Q6  Q7
+ Q8  Q9  Q10 Q11 Q12 Q13 Q14 Q15
+ QB0  QB1  QB2  QB3  QB4  QB5  QB6  QB7
+ QB8  QB9  QB10 QB11 QB12 QB13 QB14 QB15
+ SENSE_OUT0  SENSE_OUT1  SENSE_OUT2  SENSE_OUT3  SENSE_OUT4  SENSE_OUT5  SENSE_OUT6  SENSE_OUT7
+ SENSE_OUT8  SENSE_OUT9  SENSE_OUT10 SENSE_OUT11 SENSE_OUT12 SENSE_OUT13 SENSE_OUT14 SENSE_OUT15
+ SENSE_OUT16 SENSE_OUT17 SENSE_OUT18 SENSE_OUT19 SENSE_OUT20 SENSE_OUT21 SENSE_OUT22 SENSE_OUT23
+ SENSE_OUT24 SENSE_OUT25 SENSE_OUT26 SENSE_OUT27 SENSE_OUT28 SENSE_OUT29 SENSE_OUT30 SENSE_OUT31
+ SENSE_OUTB0  SENSE_OUTB1  SENSE_OUTB2  SENSE_OUTB3  SENSE_OUTB4  SENSE_OUTB5  SENSE_OUTB6  SENSE_OUTB7
+ SENSE_OUTB8  SENSE_OUTB9  SENSE_OUTB10 SENSE_OUTB11 SENSE_OUTB12 SENSE_OUTB13 SENSE_OUTB14 SENSE_OUTB15
+ SENSE_OUTB16 SENSE_OUTB17 SENSE_OUTB18 SENSE_OUTB19 SENSE_OUTB20 SENSE_OUTB21 SENSE_OUTB22 SENSE_OUTB23
+ SENSE_OUTB24 SENSE_OUTB25 SENSE_OUTB26 SENSE_OUTB27 SENSE_OUTB28 SENSE_OUTB29 SENSE_OUTB30 SENSE_OUTB31

Xsel_chain In WEN
+ sel0_0 sel0_1 sel1_0 sel1_1 sel2_0 sel2_1 sel3_0 sel3_1 SEL_CHAIN

Xsel0  sel0_0 Q0  QB0  SENSE_OUT0  SENSE_OUTB0  SEL
Xsel2  sel0_0 Q1  QB1  SENSE_OUT1  SENSE_OUTB1  SEL
Xsel4  sel0_0 Q2  QB2  SENSE_OUT2  SENSE_OUTB2  SEL
Xsel6  sel0_0 Q3  QB3  SENSE_OUT3  SENSE_OUTB3  SEL

Xsel8  sel1_0 Q4  QB4  SENSE_OUT4  SENSE_OUTB4  SEL
Xsel10 sel1_0 Q5  QB5  SENSE_OUT5  SENSE_OUTB5  SEL
Xsel12 sel1_0 Q6  QB6  SENSE_OUT6  SENSE_OUTB6  SEL
Xsel14 sel1_0 Q7  QB7  SENSE_OUT7  SENSE_OUTB7  SEL

Xsel16 sel2_0 Q8  QB8  SENSE_OUT8  SENSE_OUTB8  SEL
Xsel18 sel2_0 Q9  QB9  SENSE_OUT9  SENSE_OUTB9  SEL
Xsel20 sel2_0 Q10 QB10 SENSE_OUT10 SENSE_OUTB10 SEL
Xsel22 sel2_0 Q11 QB11 SENSE_OUT11 SENSE_OUTB11 SEL

Xsel24 sel3_0 Q12 QB12 SENSE_OUT12 SENSE_OUTB12 SEL
Xsel26 sel3_0 Q13 QB13 SENSE_OUT13 SENSE_OUTB13 SEL
Xsel28 sel3_0 Q14 QB14 SENSE_OUT14 SENSE_OUTB14 SEL
Xsel30 sel3_0 Q15 QB15 SENSE_OUT15 SENSE_OUTB15 SEL

Xsel1  sel0_1 Q0  QB0  SENSE_OUT16 SENSE_OUTB16 SEL
Xsel3  sel0_1 Q1  QB1  SENSE_OUT17 SENSE_OUTB17 SEL
Xsel5  sel0_1 Q2  QB2  SENSE_OUT18 SENSE_OUTB18 SEL
Xsel7  sel0_1 Q3  QB3  SENSE_OUT19 SENSE_OUTB19 SEL

Xsel9  sel1_1 Q4  QB4  SENSE_OUT20 SENSE_OUTB20 SEL
Xsel11 sel1_1 Q5  QB5  SENSE_OUT21 SENSE_OUTB21 SEL
Xsel13 sel1_1 Q6  QB6  SENSE_OUT22 SENSE_OUTB22 SEL
Xsel15 sel1_1 Q7  QB7  SENSE_OUT23 SENSE_OUTB23 SEL

Xsel17 sel2_1 Q8  QB8  SENSE_OUT24 SENSE_OUTB24 SEL
Xsel19 sel2_1 Q9  QB9  SENSE_OUT25 SENSE_OUTB25 SEL
Xsel21 sel2_1 Q10 QB10 SENSE_OUT26 SENSE_OUTB26 SEL
Xsel23 sel2_1 Q11 QB11 SENSE_OUT27 SENSE_OUTB27 SEL

Xsel25 sel3_1 Q12 QB12 SENSE_OUT28 SENSE_OUTB28 SEL
Xsel27 sel3_1 Q13 QB13 SENSE_OUT29 SENSE_OUTB29 SEL
Xsel29 sel3_1 Q14 QB14 SENSE_OUT30 SENSE_OUTB30 SEL
Xsel31 sel3_1 Q15 QB15 SENSE_OUT31 SENSE_OUTB31 SEL
.ends
